300 series diodes from 1 kV through 1k (0.8 A)
* bench.id: rob_cv_diode_string_300_1kv_op
* bench.group: robustness
* bench.title: 300 series diodes from 1 kV through 1k (0.8 A)
* bench.probes: v(d1), v(d150), v(d300), i(v1)
* bench.expect: match
* bench.oracle: dc_nonlinear
* bench.size: 300
* bench.est_rss_mib: 32
* bench.tags: nonlinear, diode, large_current, op
* bench.note: ngspice-47 converges directly; the same string at 300 V converges in RustSpice, as does a 400-diode string at 1 kV through 100k (small current). Calibration evidence: independent dense f64 Newton (gmin->0, gmin continuation) matches ngspice-tight to 1.6e-10 V and i(v1) to 1.6e-13 A, with its own residual 8e-13 A (rounding noise of the gd*v terms of ~1.5e4 A), i.e. the 1e-12 A absolute criterion sits at the noise floor for this deck.
V1 n0 0 1000
R1 n0 d1 1000
D1 d1 d2 dm
D2 d2 d3 dm
D3 d3 d4 dm
D4 d4 d5 dm
D5 d5 d6 dm
D6 d6 d7 dm
D7 d7 d8 dm
D8 d8 d9 dm
D9 d9 d10 dm
D10 d10 d11 dm
D11 d11 d12 dm
D12 d12 d13 dm
D13 d13 d14 dm
D14 d14 d15 dm
D15 d15 d16 dm
D16 d16 d17 dm
D17 d17 d18 dm
D18 d18 d19 dm
D19 d19 d20 dm
D20 d20 d21 dm
D21 d21 d22 dm
D22 d22 d23 dm
D23 d23 d24 dm
D24 d24 d25 dm
D25 d25 d26 dm
D26 d26 d27 dm
D27 d27 d28 dm
D28 d28 d29 dm
D29 d29 d30 dm
D30 d30 d31 dm
D31 d31 d32 dm
D32 d32 d33 dm
D33 d33 d34 dm
D34 d34 d35 dm
D35 d35 d36 dm
D36 d36 d37 dm
D37 d37 d38 dm
D38 d38 d39 dm
D39 d39 d40 dm
D40 d40 d41 dm
D41 d41 d42 dm
D42 d42 d43 dm
D43 d43 d44 dm
D44 d44 d45 dm
D45 d45 d46 dm
D46 d46 d47 dm
D47 d47 d48 dm
D48 d48 d49 dm
D49 d49 d50 dm
D50 d50 d51 dm
D51 d51 d52 dm
D52 d52 d53 dm
D53 d53 d54 dm
D54 d54 d55 dm
D55 d55 d56 dm
D56 d56 d57 dm
D57 d57 d58 dm
D58 d58 d59 dm
D59 d59 d60 dm
D60 d60 d61 dm
D61 d61 d62 dm
D62 d62 d63 dm
D63 d63 d64 dm
D64 d64 d65 dm
D65 d65 d66 dm
D66 d66 d67 dm
D67 d67 d68 dm
D68 d68 d69 dm
D69 d69 d70 dm
D70 d70 d71 dm
D71 d71 d72 dm
D72 d72 d73 dm
D73 d73 d74 dm
D74 d74 d75 dm
D75 d75 d76 dm
D76 d76 d77 dm
D77 d77 d78 dm
D78 d78 d79 dm
D79 d79 d80 dm
D80 d80 d81 dm
D81 d81 d82 dm
D82 d82 d83 dm
D83 d83 d84 dm
D84 d84 d85 dm
D85 d85 d86 dm
D86 d86 d87 dm
D87 d87 d88 dm
D88 d88 d89 dm
D89 d89 d90 dm
D90 d90 d91 dm
D91 d91 d92 dm
D92 d92 d93 dm
D93 d93 d94 dm
D94 d94 d95 dm
D95 d95 d96 dm
D96 d96 d97 dm
D97 d97 d98 dm
D98 d98 d99 dm
D99 d99 d100 dm
D100 d100 d101 dm
D101 d101 d102 dm
D102 d102 d103 dm
D103 d103 d104 dm
D104 d104 d105 dm
D105 d105 d106 dm
D106 d106 d107 dm
D107 d107 d108 dm
D108 d108 d109 dm
D109 d109 d110 dm
D110 d110 d111 dm
D111 d111 d112 dm
D112 d112 d113 dm
D113 d113 d114 dm
D114 d114 d115 dm
D115 d115 d116 dm
D116 d116 d117 dm
D117 d117 d118 dm
D118 d118 d119 dm
D119 d119 d120 dm
D120 d120 d121 dm
D121 d121 d122 dm
D122 d122 d123 dm
D123 d123 d124 dm
D124 d124 d125 dm
D125 d125 d126 dm
D126 d126 d127 dm
D127 d127 d128 dm
D128 d128 d129 dm
D129 d129 d130 dm
D130 d130 d131 dm
D131 d131 d132 dm
D132 d132 d133 dm
D133 d133 d134 dm
D134 d134 d135 dm
D135 d135 d136 dm
D136 d136 d137 dm
D137 d137 d138 dm
D138 d138 d139 dm
D139 d139 d140 dm
D140 d140 d141 dm
D141 d141 d142 dm
D142 d142 d143 dm
D143 d143 d144 dm
D144 d144 d145 dm
D145 d145 d146 dm
D146 d146 d147 dm
D147 d147 d148 dm
D148 d148 d149 dm
D149 d149 d150 dm
D150 d150 d151 dm
D151 d151 d152 dm
D152 d152 d153 dm
D153 d153 d154 dm
D154 d154 d155 dm
D155 d155 d156 dm
D156 d156 d157 dm
D157 d157 d158 dm
D158 d158 d159 dm
D159 d159 d160 dm
D160 d160 d161 dm
D161 d161 d162 dm
D162 d162 d163 dm
D163 d163 d164 dm
D164 d164 d165 dm
D165 d165 d166 dm
D166 d166 d167 dm
D167 d167 d168 dm
D168 d168 d169 dm
D169 d169 d170 dm
D170 d170 d171 dm
D171 d171 d172 dm
D172 d172 d173 dm
D173 d173 d174 dm
D174 d174 d175 dm
D175 d175 d176 dm
D176 d176 d177 dm
D177 d177 d178 dm
D178 d178 d179 dm
D179 d179 d180 dm
D180 d180 d181 dm
D181 d181 d182 dm
D182 d182 d183 dm
D183 d183 d184 dm
D184 d184 d185 dm
D185 d185 d186 dm
D186 d186 d187 dm
D187 d187 d188 dm
D188 d188 d189 dm
D189 d189 d190 dm
D190 d190 d191 dm
D191 d191 d192 dm
D192 d192 d193 dm
D193 d193 d194 dm
D194 d194 d195 dm
D195 d195 d196 dm
D196 d196 d197 dm
D197 d197 d198 dm
D198 d198 d199 dm
D199 d199 d200 dm
D200 d200 d201 dm
D201 d201 d202 dm
D202 d202 d203 dm
D203 d203 d204 dm
D204 d204 d205 dm
D205 d205 d206 dm
D206 d206 d207 dm
D207 d207 d208 dm
D208 d208 d209 dm
D209 d209 d210 dm
D210 d210 d211 dm
D211 d211 d212 dm
D212 d212 d213 dm
D213 d213 d214 dm
D214 d214 d215 dm
D215 d215 d216 dm
D216 d216 d217 dm
D217 d217 d218 dm
D218 d218 d219 dm
D219 d219 d220 dm
D220 d220 d221 dm
D221 d221 d222 dm
D222 d222 d223 dm
D223 d223 d224 dm
D224 d224 d225 dm
D225 d225 d226 dm
D226 d226 d227 dm
D227 d227 d228 dm
D228 d228 d229 dm
D229 d229 d230 dm
D230 d230 d231 dm
D231 d231 d232 dm
D232 d232 d233 dm
D233 d233 d234 dm
D234 d234 d235 dm
D235 d235 d236 dm
D236 d236 d237 dm
D237 d237 d238 dm
D238 d238 d239 dm
D239 d239 d240 dm
D240 d240 d241 dm
D241 d241 d242 dm
D242 d242 d243 dm
D243 d243 d244 dm
D244 d244 d245 dm
D245 d245 d246 dm
D246 d246 d247 dm
D247 d247 d248 dm
D248 d248 d249 dm
D249 d249 d250 dm
D250 d250 d251 dm
D251 d251 d252 dm
D252 d252 d253 dm
D253 d253 d254 dm
D254 d254 d255 dm
D255 d255 d256 dm
D256 d256 d257 dm
D257 d257 d258 dm
D258 d258 d259 dm
D259 d259 d260 dm
D260 d260 d261 dm
D261 d261 d262 dm
D262 d262 d263 dm
D263 d263 d264 dm
D264 d264 d265 dm
D265 d265 d266 dm
D266 d266 d267 dm
D267 d267 d268 dm
D268 d268 d269 dm
D269 d269 d270 dm
D270 d270 d271 dm
D271 d271 d272 dm
D272 d272 d273 dm
D273 d273 d274 dm
D274 d274 d275 dm
D275 d275 d276 dm
D276 d276 d277 dm
D277 d277 d278 dm
D278 d278 d279 dm
D279 d279 d280 dm
D280 d280 d281 dm
D281 d281 d282 dm
D282 d282 d283 dm
D283 d283 d284 dm
D284 d284 d285 dm
D285 d285 d286 dm
D286 d286 d287 dm
D287 d287 d288 dm
D288 d288 d289 dm
D289 d289 d290 dm
D290 d290 d291 dm
D291 d291 d292 dm
D292 d292 d293 dm
D293 d293 d294 dm
D294 d294 d295 dm
D295 d295 d296 dm
D296 d296 d297 dm
D297 d297 d298 dm
D298 d298 d299 dm
D299 d299 d300 dm
D300 d300 0 dm
.model dm D(is=1e-14 n=1)
.op
.end
