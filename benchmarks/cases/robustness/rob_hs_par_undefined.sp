R value {nosuch} with no such .param
* bench.id: rob_hs_par_undefined
* bench.group: robustness
* bench.title: R value {nosuch} with no such .param
* bench.probes: v(1), v(2), i(v1)
* bench.expect: loud_error
* bench.tags: hostile, param
* bench.est_rss_mib: 64
V1 1 0 5
R1 1 2 {nosuch}
R2 2 0 1k
.op
.end
