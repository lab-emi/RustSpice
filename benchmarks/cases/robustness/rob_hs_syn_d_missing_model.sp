D card without a model name
* bench.id: rob_hs_syn_d_missing_model
* bench.group: robustness
* bench.title: D card without a model name
* bench.probes: v(1), v(2), i(v1)
* bench.expect: loud_error
* bench.tags: hostile, syntax, parser
* bench.est_rss_mib: 64
V1 1 0 5
R1 1 2 1k
R2 2 0 1k
D9 2 0
.op
.end
