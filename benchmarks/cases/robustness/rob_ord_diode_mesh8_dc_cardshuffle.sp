Diode-resistor mesh 8x8, .dc 0..3 V, cards shuffled (seed 3)
* bench.id: rob_ord_diode_mesh8_dc_cardshuffle
* bench.group: robustness
* bench.title: Diode-resistor mesh 8x8, .dc 0..3 V, cards shuffled (seed 3)
* bench.probes: v(n0_0), v(n4_4), v(n7_7), i(v1)
* bench.tol.rel: 1e-7
* bench.tol.abs: 1e-8
* bench.expect: match
* bench.oracle: dc_nonlinear
* bench.size: 66
* bench.est_rss_mib: 20
* bench.tags: nonlinear, diode, mesh, dc, sweep, card_order, control, regression_anchor
* bench.note: nonlinear control with teeth: 64 diodes + 112 resistors in a 66-unknown 2-D mesh, card order shuffled by random.Random(3); dense f64 Newton oracle; measured card-order deviation of RustSpice 7.5e-14 V over 8 seeds
.model DMOD D(IS=1e-14 N=1.0)
Rv0_6 n0_6 n1_6 100
Rv4_2 n4_2 n5_2 100
Rv1_7 n1_7 n2_7 100
Rv3_2 n3_2 n4_2 100
Rv4_7 n4_7 n5_7 100
Rv3_1 n3_1 n4_1 100
D2_3 n2_3 0 DMOD
D2_5 n2_5 0 DMOD
D1_7 n1_7 0 DMOD
D6_7 n6_7 0 DMOD
Rv6_1 n6_1 n7_1 100
D1_1 n1_1 0 DMOD
D1_2 n1_2 0 DMOD
D4_6 n4_6 0 DMOD
Rh7_4 n7_4 n7_5 100
Rh5_3 n5_3 n5_4 100
D4_3 n4_3 0 DMOD
D0_4 n0_4 0 DMOD
Rh1_0 n1_0 n1_1 100
Rin in n0_0 100
Rv2_5 n2_5 n3_5 100
Rh3_4 n3_4 n3_5 100
Rh2_3 n2_3 n2_4 100
D7_3 n7_3 0 DMOD
Rh0_3 n0_3 n0_4 100
D3_0 n3_0 0 DMOD
Rh6_2 n6_2 n6_3 100
Rv2_4 n2_4 n3_4 100
Rv5_4 n5_4 n6_4 100
Rv4_3 n4_3 n5_3 100
Rh5_2 n5_2 n5_3 100
Rv2_2 n2_2 n3_2 100
D4_1 n4_1 0 DMOD
D3_3 n3_3 0 DMOD
D7_7 n7_7 0 DMOD
Rv1_6 n1_6 n2_6 100
D5_0 n5_0 0 DMOD
Rv3_3 n3_3 n4_3 100
D6_6 n6_6 0 DMOD
D0_5 n0_5 0 DMOD
Rh1_2 n1_2 n1_3 100
D3_7 n3_7 0 DMOD
Rh0_1 n0_1 n0_2 100
Rv6_0 n6_0 n7_0 100
Rh5_0 n5_0 n5_1 100
Rh6_4 n6_4 n6_5 100
Rv4_4 n4_4 n5_4 100
Rv2_0 n2_0 n3_0 100
Rh7_5 n7_5 n7_6 100
Rh7_3 n7_3 n7_4 100
D2_1 n2_1 0 DMOD
Rh5_6 n5_6 n5_7 100
Rv5_0 n5_0 n6_0 100
D0_7 n0_7 0 DMOD
Rh4_5 n4_5 n4_6 100
Rh0_6 n0_6 n0_7 100
D5_5 n5_5 0 DMOD
D3_5 n3_5 0 DMOD
Rh3_6 n3_6 n3_7 100
Rh2_6 n2_6 n2_7 100
D6_3 n6_3 0 DMOD
Rv5_3 n5_3 n6_3 100
Rh0_5 n0_5 n0_6 100
Rv3_5 n3_5 n4_5 100
D1_0 n1_0 0 DMOD
D6_1 n6_1 0 DMOD
Rh4_3 n4_3 n4_4 100
D5_6 n5_6 0 DMOD
V1 in 0 DC 3
Rv1_4 n1_4 n2_4 100
Rv0_0 n0_0 n1_0 100
Rv1_1 n1_1 n2_1 100
Rh2_5 n2_5 n2_6 100
Rv4_6 n4_6 n5_6 100
Rv2_7 n2_7 n3_7 100
Rv1_5 n1_5 n2_5 100
Rh3_1 n3_1 n3_2 100
D2_0 n2_0 0 DMOD
Rv5_6 n5_6 n6_6 100
Rh3_2 n3_2 n3_3 100
D7_6 n7_6 0 DMOD
D0_1 n0_1 0 DMOD
Rv4_0 n4_0 n5_0 100
Rv2_1 n2_1 n3_1 100
D2_2 n2_2 0 DMOD
D1_4 n1_4 0 DMOD
D0_0 n0_0 0 DMOD
Rv0_5 n0_5 n1_5 100
Rv5_1 n5_1 n6_1 100
Rh4_0 n4_0 n4_1 100
Rv5_2 n5_2 n6_2 100
D0_3 n0_3 0 DMOD
D7_5 n7_5 0 DMOD
D4_2 n4_2 0 DMOD
Rh2_4 n2_4 n2_5 100
D0_2 n0_2 0 DMOD
Rh0_4 n0_4 n0_5 100
Rv1_3 n1_3 n2_3 100
Rv5_5 n5_5 n6_5 100
D4_4 n4_4 0 DMOD
Rh3_3 n3_3 n3_4 100
Rv1_0 n1_0 n2_0 100
D3_4 n3_4 0 DMOD
Rv3_6 n3_6 n4_6 100
Rv0_3 n0_3 n1_3 100
Rh3_0 n3_0 n3_1 100
D6_4 n6_4 0 DMOD
D2_7 n2_7 0 DMOD
Rh1_5 n1_5 n1_6 100
Rh5_4 n5_4 n5_5 100
D0_6 n0_6 0 DMOD
D3_6 n3_6 0 DMOD
Rv3_4 n3_4 n4_4 100
D5_4 n5_4 0 DMOD
Rh1_3 n1_3 n1_4 100
D7_0 n7_0 0 DMOD
Rh6_3 n6_3 n6_4 100
Rh3_5 n3_5 n3_6 100
D1_6 n1_6 0 DMOD
D4_7 n4_7 0 DMOD
Rh1_1 n1_1 n1_2 100
D5_2 n5_2 0 DMOD
Rh2_1 n2_1 n2_2 100
D3_1 n3_1 0 DMOD
Rh6_1 n6_1 n6_2 100
Rh1_6 n1_6 n1_7 100
Rv3_0 n3_0 n4_0 100
Rh4_1 n4_1 n4_2 100
Rh4_4 n4_4 n4_5 100
D6_2 n6_2 0 DMOD
Rv4_5 n4_5 n5_5 100
Rh7_0 n7_0 n7_1 100
Rh2_2 n2_2 n2_3 100
D5_3 n5_3 0 DMOD
Rh6_6 n6_6 n6_7 100
Rh0_2 n0_2 n0_3 100
Rv0_7 n0_7 n1_7 100
Rv3_7 n3_7 n4_7 100
D1_3 n1_3 0 DMOD
Rh4_6 n4_6 n4_7 100
Rh6_5 n6_5 n6_6 100
D4_5 n4_5 0 DMOD
Rh7_6 n7_6 n7_7 100
Rv6_5 n6_5 n7_5 100
Rv2_6 n2_6 n3_6 100
Rv0_1 n0_1 n1_1 100
D3_2 n3_2 0 DMOD
Rv0_2 n0_2 n1_2 100
D1_5 n1_5 0 DMOD
Rh7_2 n7_2 n7_3 100
Rh7_1 n7_1 n7_2 100
Rv4_1 n4_1 n5_1 100
Rh5_5 n5_5 n5_6 100
D7_2 n7_2 0 DMOD
Rv6_7 n6_7 n7_7 100
Rh1_4 n1_4 n1_5 100
Rh4_2 n4_2 n4_3 100
D7_4 n7_4 0 DMOD
D6_0 n6_0 0 DMOD
D5_7 n5_7 0 DMOD
D7_1 n7_1 0 DMOD
Rh2_0 n2_0 n2_1 100
Rv2_3 n2_3 n3_3 100
Rh6_0 n6_0 n6_1 100
D2_6 n2_6 0 DMOD
D5_1 n5_1 0 DMOD
Rh0_0 n0_0 n0_1 100
D6_5 n6_5 0 DMOD
Rv0_4 n0_4 n1_4 100
Rv6_2 n6_2 n7_2 100
Rv6_6 n6_6 n7_6 100
Rh5_1 n5_1 n5_2 100
Rv6_4 n6_4 n7_4 100
D4_0 n4_0 0 DMOD
Rv1_2 n1_2 n2_2 100
Rv5_7 n5_7 n6_7 100
Rv6_3 n6_3 n7_3 100
D2_4 n2_4 0 DMOD
.dc V1 0 3 0.1
.end
