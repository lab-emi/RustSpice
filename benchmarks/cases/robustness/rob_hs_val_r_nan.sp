R value nan
* bench.id: rob_hs_val_r_nan
* bench.group: robustness
* bench.title: R value nan
* bench.probes: v(1), v(2), i(v1)
* bench.expect: loud_error
* bench.tags: hostile, value, nonfinite
* bench.est_rss_mib: 64
V1 1 0 5
R1 1 2 1k
R2 2 0 nan
.op
.end
