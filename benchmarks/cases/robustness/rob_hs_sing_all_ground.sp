every element connected to node 0 only
* bench.id: rob_hs_sing_all_ground
* bench.group: robustness
* bench.title: every element connected to node 0 only
* bench.probes: v(1)
* bench.expect: loud_error
* bench.tags: hostile, singular, dc
* bench.est_rss_mib: 64
R1 0 0 1k
V1 0 0 0
.op
.end
