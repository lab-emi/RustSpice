everything in upper case (nodes, values, cards)
* bench.id: rob_hs_ff_uppercase
* bench.group: robustness
* bench.title: everything in upper case (nodes, values, cards)
* bench.probes: v(in), v(out), i(v1)
* bench.expect: match
* bench.tags: file, parser, lenient_ok
* bench.est_rss_mib: 64
V1 IN 0 DC 5V
R1 IN OUT 1K
R2 OUT 0 1K
.OP
.END
