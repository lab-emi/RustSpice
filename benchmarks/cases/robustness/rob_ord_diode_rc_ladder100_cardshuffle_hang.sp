Diode-clamped 100-stage RC line of perf_med_diode_rc_ladder_tran_100, cards shuffled (seed 2)
* bench.id: rob_ord_diode_rc_ladder100_cardshuffle_hang
* bench.group: robustness
* bench.title: Diode-clamped 100-stage RC line of perf_med_diode_rc_ladder_tran_100, cards shuffled (seed 2)
* bench.probes: v(n1), v(n50), v(n100), i(v1)
* bench.tol.norm: 1.1e-3
* bench.expect: match
* bench.ref: reltol=1e-6 abstol=1e-15 vntol=1e-9
* bench.ref.tmax: 0.05n
* bench.size: 103
* bench.est_rss_mib: 40
* bench.tags: nonlinear, tran, ladder, diode, card_order, runtime_cliff, corpus_copy
* bench.note: metamorphic copy of perf_med_diode_rc_ladder_tran_100 (103 unknowns): identical circuit and .tran, cards shuffled (card order of random.Random(2) after a label shuffle, node names restored); the natural-order original runs in 0.2 s and passes; this order needs minutes, so the case timeout decides. When the run is allowed to finish the waveform is right (checked once by hand after a 362 s run), so the cost is runtime, not values
.model dm D(IS=1e-14 N=1)
C100 n100 0 1p
C91 n91 0 1p
R74 n73 n74 100
D62 n62 0 dm
R53 n52 n53 100
C49 n49 0 1p
D28 n28 0 dm
C16 n16 0 1p
C62 n62 0 1p
C24 n24 0 1p
C94 n94 0 1p
D6 n6 0 dm
D23 n23 0 dm
D78 n78 0 dm
R40 n39 n40 100
R70 n69 n70 100
C78 n78 0 1p
R57 n56 n57 100
D38 n38 0 dm
D67 n67 0 dm
C39 n39 0 1p
C45 n45 0 1p
C87 n87 0 1p
R95 n94 n95 100
C51 n51 0 1p
R19 n18 n19 100
D69 n69 0 dm
D13 n13 0 dm
R73 n72 n73 100
D27 n27 0 dm
C71 n71 0 1p
R83 n82 n83 100
R34 n33 n34 100
C7 n7 0 1p
R72 n71 n72 100
R69 n68 n69 100
C86 n86 0 1p
C81 n81 0 1p
C40 n40 0 1p
C17 n17 0 1p
D16 n16 0 dm
D37 n37 0 dm
R81 n80 n81 100
D96 n96 0 dm
C82 n82 0 1p
D55 n55 0 dm
D85 n85 0 dm
D52 n52 0 dm
D80 n80 0 dm
D83 n83 0 dm
D49 n49 0 dm
D25 n25 0 dm
C50 n50 0 1p
R67 n66 n67 100
C30 n30 0 1p
D77 n77 0 dm
C69 n69 0 1p
D94 n94 0 dm
R58 n57 n58 100
D10 n10 0 dm
C28 n28 0 1p
R94 n93 n94 100
R85 n84 n85 100
C52 n52 0 1p
C41 n41 0 1p
D75 n75 0 dm
R23 n22 n23 100
C77 n77 0 1p
C55 n55 0 1p
D91 n91 0 dm
C96 n96 0 1p
R63 n62 n63 100
D93 n93 0 dm
C15 n15 0 1p
D12 n12 0 dm
C64 n64 0 1p
D48 n48 0 dm
C20 n20 0 1p
D35 n35 0 dm
C48 n48 0 1p
C9 n9 0 1p
R30 n29 n30 100
C92 n92 0 1p
R37 n36 n37 100
D90 n90 0 dm
R98 n97 n98 100
C93 n93 0 1p
C75 n75 0 1p
C5 n5 0 1p
R89 n88 n89 100
R15 n14 n15 100
R6 n5 n6 100
D82 n82 0 dm
D30 n30 0 dm
R17 n16 n17 100
C79 n79 0 1p
D24 n24 0 dm
D68 n68 0 dm
R47 n46 n47 100
C76 n76 0 1p
C32 n32 0 1p
C56 n56 0 1p
D36 n36 0 dm
R80 n79 n80 100
D87 n87 0 dm
R16 n15 n16 100
C1 n1 0 1p
D72 n72 0 dm
D88 n88 0 dm
C85 n85 0 1p
D70 n70 0 dm
C25 n25 0 1p
R93 n92 n93 100
D53 n53 0 dm
R21 n20 n21 100
C27 n27 0 1p
D17 n17 0 dm
D84 n84 0 dm
R79 n78 n79 100
D34 n34 0 dm
D86 n86 0 dm
C43 n43 0 1p
R29 n28 n29 100
C33 n33 0 1p
R48 n47 n48 100
R43 n42 n43 100
D79 n79 0 dm
D63 n63 0 dm
D54 n54 0 dm
C35 n35 0 1p
R51 n50 n51 100
C84 n84 0 1p
R32 n31 n32 100
R25 n24 n25 100
C46 n46 0 1p
C95 n95 0 1p
R75 n74 n75 100
C70 n70 0 1p
C31 n31 0 1p
R41 n40 n41 100
C74 n74 0 1p
R54 n53 n54 100
D59 n59 0 dm
R71 n70 n71 100
D4 n4 0 dm
C88 n88 0 1p
C65 n65 0 1p
C59 n59 0 1p
C37 n37 0 1p
R18 n17 n18 100
C97 n97 0 1p
D99 n99 0 dm
R46 n45 n46 100
D26 n26 0 dm
C66 n66 0 1p
D39 n39 0 dm
D44 n44 0 dm
D76 n76 0 dm
D18 n18 0 dm
R55 n54 n55 100
C90 n90 0 1p
D15 n15 0 dm
R2 n1 n2 100
D98 n98 0 dm
R82 n81 n82 100
D20 n20 0 dm
R88 n87 n88 100
C73 n73 0 1p
D9 n9 0 dm
R76 n75 n76 100
R35 n34 n35 100
R33 n32 n33 100
C3 n3 0 1p
D100 n100 0 dm
Rs s n0 200
R45 n44 n45 100
R24 n23 n24 100
C36 n36 0 1p
R78 n77 n78 100
D89 n89 0 dm
R31 n30 n31 100
R65 n64 n65 100
C61 n61 0 1p
C80 n80 0 1p
R92 n91 n92 100
D50 n50 0 dm
R91 n90 n91 100
C68 n68 0 1p
R87 n86 n87 100
R38 n37 n38 100
R61 n60 n61 100
C83 n83 0 1p
C21 n21 0 1p
R68 n67 n68 100
D60 n60 0 dm
R90 n89 n90 100
R20 n19 n20 100
C54 n54 0 1p
D97 n97 0 dm
C8 n8 0 1p
D14 n14 0 dm
R14 n13 n14 100
C11 n11 0 1p
R3 n2 n3 100
D21 n21 0 dm
R5 n4 n5 100
C57 n57 0 1p
R12 n11 n12 100
D47 n47 0 dm
R60 n59 n60 100
R100 n99 n100 100
R56 n55 n56 100
D95 n95 0 dm
R52 n51 n52 100
D81 n81 0 dm
C22 n22 0 1p
C29 n29 0 1p
C12 n12 0 1p
R28 n27 n28 100
R44 n43 n44 100
D41 n41 0 dm
D33 n33 0 dm
D66 n66 0 dm
R50 n49 n50 100
C44 n44 0 1p
R11 n10 n11 100
D74 n74 0 dm
C67 n67 0 1p
R84 n83 n84 100
C2 n2 0 1p
R9 n8 n9 100
D71 n71 0 dm
R97 n96 n97 100
D58 n58 0 dm
D56 n56 0 dm
R8 n7 n8 100
R86 n85 n86 100
D40 n40 0 dm
C13 n13 0 1p
C60 n60 0 1p
C53 n53 0 1p
D73 n73 0 dm
C34 n34 0 1p
D64 n64 0 dm
D22 n22 0 dm
R77 n76 n77 100
R4 n3 n4 100
C63 n63 0 1p
D51 n51 0 dm
D65 n65 0 dm
C47 n47 0 1p
C38 n38 0 1p
C26 n26 0 1p
D2 n2 0 dm
R96 n95 n96 100
D57 n57 0 dm
R49 n48 n49 100
C19 n19 0 1p
R59 n58 n59 100
R1 n0 n1 100
C6 n6 0 1p
R26 n25 n26 100
C42 n42 0 1p
D7 n7 0 dm
R66 n65 n66 100
V1 s 0 PULSE(0 3 1n 20n 20n 150n 400n)
D31 n31 0 dm
R27 n26 n27 100
R22 n21 n22 100
D43 n43 0 dm
R64 n63 n64 100
D3 n3 0 dm
R7 n6 n7 100
D92 n92 0 dm
D11 n11 0 dm
D19 n19 0 dm
C14 n14 0 1p
C4 n4 0 1p
D42 n42 0 dm
D29 n29 0 dm
D61 n61 0 dm
R62 n61 n62 100
R10 n9 n10 100
D5 n5 0 dm
C72 n72 0 1p
R99 n98 n99 100
R36 n35 n36 100
R42 n41 n42 100
D45 n45 0 dm
C23 n23 0 1p
C89 n89 0 1p
C99 n99 0 1p
R39 n38 n39 100
D46 n46 0 dm
D8 n8 0 dm
C98 n98 0 1p
C10 n10 0 1p
C18 n18 0 1p
D32 n32 0 dm
D1 n1 0 dm
C58 n58 0 1p
R13 n12 n13 100
.tran 0.2n 400n
.end
