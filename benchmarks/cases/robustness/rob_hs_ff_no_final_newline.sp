last line '.end' without a trailing newline
* bench.id: rob_hs_ff_no_final_newline
* bench.group: robustness
* bench.title: last line '.end' without a trailing newline
* bench.probes: v(1), v(2), i(v1)
* bench.expect: match
* bench.tags: file, lenient_ok
* bench.est_rss_mib: 64
V1 1 0 5
R1 1 2 1k
R2 2 0 1k
.op
.end
