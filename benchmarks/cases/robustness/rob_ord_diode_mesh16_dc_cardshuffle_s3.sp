Diode-resistor mesh 16x16, .dc 0..3 V, cards shuffled (seed 3)
* bench.id: rob_ord_diode_mesh16_dc_cardshuffle_s3
* bench.group: robustness
* bench.title: Diode-resistor mesh 16x16, .dc 0..3 V, cards shuffled (seed 3)
* bench.probes: v(n0_0), v(n8_8), v(n15_15), i(v1)
* bench.tol.rel: 1e-7
* bench.tol.abs: 1e-8
* bench.expect: match
* bench.size: 258
* bench.est_rss_mib: 20
* bench.tags: nonlinear, diode, mesh, dc, sweep, card_order, loud_failure
* bench.note: same family as the 8x8 control but 258 unknowns and card order from random.Random(3); natural order and 8 of 12 shuffles converge to within 9.1e-10 of swing of each other, 4 of 12 (seeds 3, 7, 9, 10) stop with a ConvergenceFailure; tolerances as in fam_diode_mesh
.model DMOD D(IS=1e-14 N=1.0)
Rv4_13 n4_13 n5_13 100
Rh10_1 n10_1 n10_2 100
Rh9_13 n9_13 n9_14 100
D7_2 n7_2 0 DMOD
D2_7 n2_7 0 DMOD
Rv2_11 n2_11 n3_11 100
Rv14_1 n14_1 n15_1 100
Rv14_8 n14_8 n15_8 100
Rh15_7 n15_7 n15_8 100
Rv13_0 n13_0 n14_0 100
D8_4 n8_4 0 DMOD
D5_5 n5_5 0 DMOD
Rh12_0 n12_0 n12_1 100
Rh15_8 n15_8 n15_9 100
D15_6 n15_6 0 DMOD
Rh1_2 n1_2 n1_3 100
D14_2 n14_2 0 DMOD
D13_5 n13_5 0 DMOD
D9_6 n9_6 0 DMOD
Rv10_15 n10_15 n11_15 100
D3_14 n3_14 0 DMOD
D13_10 n13_10 0 DMOD
Rv10_14 n10_14 n11_14 100
Rh13_4 n13_4 n13_5 100
Rh1_3 n1_3 n1_4 100
Rh15_13 n15_13 n15_14 100
D0_13 n0_13 0 DMOD
Rv5_3 n5_3 n6_3 100
Rv3_10 n3_10 n4_10 100
Rv4_15 n4_15 n5_15 100
D13_4 n13_4 0 DMOD
Rh5_0 n5_0 n5_1 100
D3_0 n3_0 0 DMOD
Rv9_8 n9_8 n10_8 100
D15_7 n15_7 0 DMOD
Rv4_5 n4_5 n5_5 100
Rv8_0 n8_0 n9_0 100
Rh2_2 n2_2 n2_3 100
D15_11 n15_11 0 DMOD
Rv4_12 n4_12 n5_12 100
D5_7 n5_7 0 DMOD
D11_4 n11_4 0 DMOD
Rh14_5 n14_5 n14_6 100
Rv1_14 n1_14 n2_14 100
Rh12_1 n12_1 n12_2 100
D1_13 n1_13 0 DMOD
D9_8 n9_8 0 DMOD
D10_14 n10_14 0 DMOD
D12_14 n12_14 0 DMOD
Rh8_3 n8_3 n8_4 100
Rh3_11 n3_11 n3_12 100
Rv0_11 n0_11 n1_11 100
D9_5 n9_5 0 DMOD
Rh12_8 n12_8 n12_9 100
D9_11 n9_11 0 DMOD
Rh7_11 n7_11 n7_12 100
Rv9_1 n9_1 n10_1 100
Rh13_3 n13_3 n13_4 100
D7_4 n7_4 0 DMOD
D12_6 n12_6 0 DMOD
D7_5 n7_5 0 DMOD
D15_5 n15_5 0 DMOD
Rh1_7 n1_7 n1_8 100
Rh9_4 n9_4 n9_5 100
D10_11 n10_11 0 DMOD
Rh11_2 n11_2 n11_3 100
Rv6_6 n6_6 n7_6 100
D7_14 n7_14 0 DMOD
Rv3_8 n3_8 n4_8 100
Rv11_2 n11_2 n12_2 100
Rh1_9 n1_9 n1_10 100
Rh7_6 n7_6 n7_7 100
Rh4_11 n4_11 n4_12 100
Rv8_12 n8_12 n9_12 100
Rh2_4 n2_4 n2_5 100
Rh3_9 n3_9 n3_10 100
Rv11_6 n11_6 n12_6 100
Rv8_7 n8_7 n9_7 100
Rv5_7 n5_7 n6_7 100
D3_9 n3_9 0 DMOD
Rv1_7 n1_7 n2_7 100
Rh3_1 n3_1 n3_2 100
Rv2_10 n2_10 n3_10 100
Rv7_9 n7_9 n8_9 100
Rv2_0 n2_0 n3_0 100
Rh10_7 n10_7 n10_8 100
Rv13_12 n13_12 n14_12 100
Rv7_4 n7_4 n8_4 100
Rv3_5 n3_5 n4_5 100
Rh14_4 n14_4 n14_5 100
D3_5 n3_5 0 DMOD
Rv1_2 n1_2 n2_2 100
D10_8 n10_8 0 DMOD
D10_13 n10_13 0 DMOD
D4_1 n4_1 0 DMOD
Rh4_5 n4_5 n4_6 100
Rh1_13 n1_13 n1_14 100
Rv12_14 n12_14 n13_14 100
Rv12_13 n12_13 n13_13 100
Rh3_4 n3_4 n3_5 100
Rv6_14 n6_14 n7_14 100
D0_1 n0_1 0 DMOD
Rh5_7 n5_7 n5_8 100
D15_12 n15_12 0 DMOD
Rv10_12 n10_12 n11_12 100
Rv14_0 n14_0 n15_0 100
Rv10_11 n10_11 n11_11 100
Rh11_6 n11_6 n11_7 100
D14_0 n14_0 0 DMOD
D12_1 n12_1 0 DMOD
Rh10_10 n10_10 n10_11 100
Rv10_3 n10_3 n11_3 100
D5_10 n5_10 0 DMOD
Rh3_6 n3_6 n3_7 100
D2_0 n2_0 0 DMOD
Rv9_0 n9_0 n10_0 100
Rv4_11 n4_11 n5_11 100
Rv6_11 n6_11 n7_11 100
D0_2 n0_2 0 DMOD
D11_10 n11_10 0 DMOD
D11_11 n11_11 0 DMOD
Rh11_10 n11_10 n11_11 100
Rv11_3 n11_3 n12_3 100
D4_6 n4_6 0 DMOD
Rh7_8 n7_8 n7_9 100
Rv13_14 n13_14 n14_14 100
Rv5_2 n5_2 n6_2 100
Rh11_13 n11_13 n11_14 100
D5_1 n5_1 0 DMOD
D3_11 n3_11 0 DMOD
Rh13_6 n13_6 n13_7 100
D3_13 n3_13 0 DMOD
Rh6_6 n6_6 n6_7 100
Rh10_12 n10_12 n10_13 100
D3_3 n3_3 0 DMOD
D9_15 n9_15 0 DMOD
D0_12 n0_12 0 DMOD
Rh8_0 n8_0 n8_1 100
Rh3_2 n3_2 n3_3 100
Rh15_0 n15_0 n15_1 100
D13_13 n13_13 0 DMOD
Rh2_11 n2_11 n2_12 100
D2_10 n2_10 0 DMOD
Rh14_3 n14_3 n14_4 100
Rh15_1 n15_1 n15_2 100
Rh9_3 n9_3 n9_4 100
Rh3_0 n3_0 n3_1 100
D6_3 n6_3 0 DMOD
Rh14_10 n14_10 n14_11 100
Rv7_14 n7_14 n8_14 100
Rh8_1 n8_1 n8_2 100
D6_1 n6_1 0 DMOD
D1_15 n1_15 0 DMOD
D11_3 n11_3 0 DMOD
D15_14 n15_14 0 DMOD
Rh0_7 n0_7 n0_8 100
Rv8_14 n8_14 n9_14 100
D15_1 n15_1 0 DMOD
Rh2_5 n2_5 n2_6 100
Rv8_15 n8_15 n9_15 100
Rv13_4 n13_4 n14_4 100
Rh12_2 n12_2 n12_3 100
D1_7 n1_7 0 DMOD
Rv12_1 n12_1 n13_1 100
Rh11_9 n11_9 n11_10 100
Rh14_9 n14_9 n14_10 100
Rv13_3 n13_3 n14_3 100
Rh2_1 n2_1 n2_2 100
Rv7_10 n7_10 n8_10 100
D3_2 n3_2 0 DMOD
D3_7 n3_7 0 DMOD
Rh1_1 n1_1 n1_2 100
Rv0_5 n0_5 n1_5 100
Rh2_9 n2_9 n2_10 100
Rv5_4 n5_4 n6_4 100
Rv12_11 n12_11 n13_11 100
Rv1_11 n1_11 n2_11 100
D1_12 n1_12 0 DMOD
Rh10_14 n10_14 n10_15 100
Rv8_4 n8_4 n9_4 100
Rh1_12 n1_12 n1_13 100
Rv7_0 n7_0 n8_0 100
Rh4_14 n4_14 n4_15 100
Rh2_6 n2_6 n2_7 100
D6_13 n6_13 0 DMOD
Rv6_15 n6_15 n7_15 100
Rh1_8 n1_8 n1_9 100
Rh15_10 n15_10 n15_11 100
Rv11_5 n11_5 n12_5 100
Rh0_9 n0_9 n0_10 100
Rh14_11 n14_11 n14_12 100
Rh3_14 n3_14 n3_15 100
D11_12 n11_12 0 DMOD
D2_4 n2_4 0 DMOD
Rv13_8 n13_8 n14_8 100
Rh8_10 n8_10 n8_11 100
Rv11_8 n11_8 n12_8 100
Rh15_12 n15_12 n15_13 100
Rh4_6 n4_6 n4_7 100
Rv10_10 n10_10 n11_10 100
Rh5_14 n5_14 n5_15 100
Rh10_6 n10_6 n10_7 100
Rh11_0 n11_0 n11_1 100
Rv12_2 n12_2 n13_2 100
Rh9_9 n9_9 n9_10 100
D14_5 n14_5 0 DMOD
Rh6_3 n6_3 n6_4 100
Rv0_15 n0_15 n1_15 100
Rh15_5 n15_5 n15_6 100
Rh8_5 n8_5 n8_6 100
Rv13_15 n13_15 n14_15 100
Rv10_8 n10_8 n11_8 100
Rv3_9 n3_9 n4_9 100
Rh12_12 n12_12 n12_13 100
Rh3_13 n3_13 n3_14 100
D9_1 n9_1 0 DMOD
Rv1_3 n1_3 n2_3 100
D7_15 n7_15 0 DMOD
Rv4_14 n4_14 n5_14 100
D5_6 n5_6 0 DMOD
D11_6 n11_6 0 DMOD
Rh4_3 n4_3 n4_4 100
D2_2 n2_2 0 DMOD
Rv11_0 n11_0 n12_0 100
Rh6_9 n6_9 n6_10 100
Rh11_8 n11_8 n11_9 100
Rv9_12 n9_12 n10_12 100
Rh15_11 n15_11 n15_12 100
Rv2_15 n2_15 n3_15 100
Rh14_2 n14_2 n14_3 100
Rv4_6 n4_6 n5_6 100
Rv11_7 n11_7 n12_7 100
Rv4_7 n4_7 n5_7 100
Rv3_1 n3_1 n4_1 100
Rv2_7 n2_7 n3_7 100
Rv7_1 n7_1 n8_1 100
D6_10 n6_10 0 DMOD
Rv6_1 n6_1 n7_1 100
Rh5_5 n5_5 n5_6 100
Rv3_11 n3_11 n4_11 100
Rv11_15 n11_15 n12_15 100
Rv7_8 n7_8 n8_8 100
Rh4_10 n4_10 n4_11 100
Rv4_2 n4_2 n5_2 100
D11_2 n11_2 0 DMOD
D7_9 n7_9 0 DMOD
D10_6 n10_6 0 DMOD
Rh6_10 n6_10 n6_11 100
D9_3 n9_3 0 DMOD
D14_1 n14_1 0 DMOD
D12_3 n12_3 0 DMOD
Rv8_6 n8_6 n9_6 100
D9_13 n9_13 0 DMOD
D12_12 n12_12 0 DMOD
Rh15_2 n15_2 n15_3 100
Rv12_9 n12_9 n13_9 100
Rv3_4 n3_4 n4_4 100
Rh7_10 n7_10 n7_11 100
Rh9_2 n9_2 n9_3 100
D5_15 n5_15 0 DMOD
Rv3_2 n3_2 n4_2 100
Rh2_7 n2_7 n2_8 100
Rv7_12 n7_12 n8_12 100
Rv8_11 n8_11 n9_11 100
Rv1_8 n1_8 n2_8 100
Rv9_10 n9_10 n10_10 100
Rv12_7 n12_7 n13_7 100
Rv1_6 n1_6 n2_6 100
Rv1_15 n1_15 n2_15 100
D4_12 n4_12 0 DMOD
D5_14 n5_14 0 DMOD
Rv5_13 n5_13 n6_13 100
Rh7_13 n7_13 n7_14 100
D1_0 n1_0 0 DMOD
Rh1_11 n1_11 n1_12 100
D1_9 n1_9 0 DMOD
D4_5 n4_5 0 DMOD
D1_10 n1_10 0 DMOD
D13_3 n13_3 0 DMOD
D13_8 n13_8 0 DMOD
Rh4_7 n4_7 n4_8 100
D1_11 n1_11 0 DMOD
D15_4 n15_4 0 DMOD
Rv14_11 n14_11 n15_11 100
Rh5_6 n5_6 n5_7 100
Rh6_13 n6_13 n6_14 100
Rh0_13 n0_13 n0_14 100
Rh8_4 n8_4 n8_5 100
D8_5 n8_5 0 DMOD
Rh15_4 n15_4 n15_5 100
Rh4_4 n4_4 n4_5 100
D3_15 n3_15 0 DMOD
Rv9_13 n9_13 n10_13 100
Rv4_3 n4_3 n5_3 100
D4_14 n4_14 0 DMOD
Rv9_3 n9_3 n10_3 100
D6_5 n6_5 0 DMOD
Rh11_7 n11_7 n11_8 100
Rh0_12 n0_12 n0_13 100
Rh1_14 n1_14 n1_15 100
D6_9 n6_9 0 DMOD
Rv7_6 n7_6 n8_6 100
Rv5_14 n5_14 n6_14 100
Rv10_5 n10_5 n11_5 100
Rh6_7 n6_7 n6_8 100
Rv1_0 n1_0 n2_0 100
Rv5_15 n5_15 n6_15 100
Rv1_1 n1_1 n2_1 100
Rh9_8 n9_8 n9_9 100
Rv12_0 n12_0 n13_0 100
D5_8 n5_8 0 DMOD
D6_14 n6_14 0 DMOD
Rh0_5 n0_5 n0_6 100
Rv13_9 n13_9 n14_9 100
Rh10_2 n10_2 n10_3 100
D6_4 n6_4 0 DMOD
Rv3_0 n3_0 n4_0 100
D14_13 n14_13 0 DMOD
Rv9_14 n9_14 n10_14 100
Rh15_9 n15_9 n15_10 100
D12_10 n12_10 0 DMOD
Rh9_14 n9_14 n9_15 100
Rh0_3 n0_3 n0_4 100
D12_0 n12_0 0 DMOD
Rv7_3 n7_3 n8_3 100
Rh1_0 n1_0 n1_1 100
Rv13_7 n13_7 n14_7 100
D0_15 n0_15 0 DMOD
Rv9_2 n9_2 n10_2 100
Rv7_15 n7_15 n8_15 100
Rh8_8 n8_8 n8_9 100
D2_8 n2_8 0 DMOD
D1_8 n1_8 0 DMOD
Rv11_1 n11_1 n12_1 100
D0_0 n0_0 0 DMOD
D8_8 n8_8 0 DMOD
D1_1 n1_1 0 DMOD
Rv5_11 n5_11 n6_11 100
Rh6_1 n6_1 n6_2 100
D14_15 n14_15 0 DMOD
D1_2 n1_2 0 DMOD
Rv11_10 n11_10 n12_10 100
Rv4_0 n4_0 n5_0 100
Rh5_11 n5_11 n5_12 100
Rv12_6 n12_6 n13_6 100
Rv14_12 n14_12 n15_12 100
D14_4 n14_4 0 DMOD
Rh9_10 n9_10 n9_11 100
Rv11_14 n11_14 n12_14 100
D14_3 n14_3 0 DMOD
D8_2 n8_2 0 DMOD
Rv3_7 n3_7 n4_7 100
D0_4 n0_4 0 DMOD
Rv1_5 n1_5 n2_5 100
Rh4_9 n4_9 n4_10 100
D2_6 n2_6 0 DMOD
D4_9 n4_9 0 DMOD
Rv8_9 n8_9 n9_9 100
D6_6 n6_6 0 DMOD
D7_12 n7_12 0 DMOD
Rv13_10 n13_10 n14_10 100
Rv10_0 n10_0 n11_0 100
D2_5 n2_5 0 DMOD
Rh10_9 n10_9 n10_10 100
Rh0_2 n0_2 n0_3 100
Rv8_1 n8_1 n9_1 100
D4_8 n4_8 0 DMOD
Rh13_13 n13_13 n13_14 100
Rh4_8 n4_8 n4_9 100
D8_10 n8_10 0 DMOD
Rv14_5 n14_5 n15_5 100
Rv5_5 n5_5 n6_5 100
Rv9_5 n9_5 n10_5 100
D4_0 n4_0 0 DMOD
D10_0 n10_0 0 DMOD
Rv13_6 n13_6 n14_6 100
Rh6_11 n6_11 n6_12 100
D12_5 n12_5 0 DMOD
Rv6_13 n6_13 n7_13 100
Rv8_3 n8_3 n9_3 100
Rh11_3 n11_3 n11_4 100
Rh7_0 n7_0 n7_1 100
Rh6_8 n6_8 n6_9 100
D4_15 n4_15 0 DMOD
Rh11_12 n11_12 n11_13 100
Rh12_4 n12_4 n12_5 100
D1_14 n1_14 0 DMOD
D6_2 n6_2 0 DMOD
Rv0_12 n0_12 n1_12 100
Rh4_1 n4_1 n4_2 100
D7_13 n7_13 0 DMOD
Rv7_11 n7_11 n8_11 100
Rin in n0_0 100
D6_0 n6_0 0 DMOD
D14_8 n14_8 0 DMOD
D13_12 n13_12 0 DMOD
Rv4_9 n4_9 n5_9 100
Rh3_8 n3_8 n3_9 100
Rh2_0 n2_0 n2_1 100
D2_13 n2_13 0 DMOD
Rv3_13 n3_13 n4_13 100
D15_2 n15_2 0 DMOD
D13_11 n13_11 0 DMOD
D4_3 n4_3 0 DMOD
D7_0 n7_0 0 DMOD
Rh4_2 n4_2 n4_3 100
D3_12 n3_12 0 DMOD
D11_1 n11_1 0 DMOD
Rv8_10 n8_10 n9_10 100
Rh1_10 n1_10 n1_11 100
D3_6 n3_6 0 DMOD
Rh5_4 n5_4 n5_5 100
D15_9 n15_9 0 DMOD
Rv5_8 n5_8 n6_8 100
D0_14 n0_14 0 DMOD
D7_11 n7_11 0 DMOD
Rv0_4 n0_4 n1_4 100
Rh5_3 n5_3 n5_4 100
D0_11 n0_11 0 DMOD
D15_0 n15_0 0 DMOD
Rv1_4 n1_4 n2_4 100
D10_9 n10_9 0 DMOD
D12_15 n12_15 0 DMOD
Rh14_12 n14_12 n14_13 100
Rv0_8 n0_8 n1_8 100
V1 in 0 DC 3
Rh11_1 n11_1 n11_2 100
Rh8_6 n8_6 n8_7 100
Rh3_7 n3_7 n3_8 100
Rv5_1 n5_1 n6_1 100
D0_8 n0_8 0 DMOD
Rh14_0 n14_0 n14_1 100
Rv5_9 n5_9 n6_9 100
Rv14_2 n14_2 n15_2 100
Rv6_10 n6_10 n7_10 100
Rv14_10 n14_10 n15_10 100
Rh13_14 n13_14 n13_15 100
D2_14 n2_14 0 DMOD
D8_3 n8_3 0 DMOD
Rv10_4 n10_4 n11_4 100
Rh15_14 n15_14 n15_15 100
Rv6_2 n6_2 n7_2 100
D13_1 n13_1 0 DMOD
D5_4 n5_4 0 DMOD
Rh0_0 n0_0 n0_1 100
Rh8_14 n8_14 n8_15 100
Rv14_15 n14_15 n15_15 100
Rh8_11 n8_11 n8_12 100
Rv2_14 n2_14 n3_14 100
D8_9 n8_9 0 DMOD
D10_2 n10_2 0 DMOD
Rh15_6 n15_6 n15_7 100
Rh10_3 n10_3 n10_4 100
Rh8_13 n8_13 n8_14 100
Rv9_9 n9_9 n10_9 100
D13_15 n13_15 0 DMOD
Rv12_4 n12_4 n13_4 100
Rv10_6 n10_6 n11_6 100
Rv2_5 n2_5 n3_5 100
Rh3_12 n3_12 n3_13 100
Rv14_13 n14_13 n15_13 100
Rh8_7 n8_7 n8_8 100
Rh8_12 n8_12 n8_13 100
D11_13 n11_13 0 DMOD
D5_13 n5_13 0 DMOD
D10_12 n10_12 0 DMOD
D2_11 n2_11 0 DMOD
D13_14 n13_14 0 DMOD
Rh3_10 n3_10 n3_11 100
D1_3 n1_3 0 DMOD
Rv6_9 n6_9 n7_9 100
Rv10_13 n10_13 n11_13 100
Rh13_7 n13_7 n13_8 100
D4_7 n4_7 0 DMOD
Rh5_12 n5_12 n5_13 100
Rh5_10 n5_10 n5_11 100
Rv0_2 n0_2 n1_2 100
Rv7_2 n7_2 n8_2 100
Rv2_8 n2_8 n3_8 100
Rh3_3 n3_3 n3_4 100
Rv12_3 n12_3 n13_3 100
D11_5 n11_5 0 DMOD
D10_10 n10_10 0 DMOD
D8_1 n8_1 0 DMOD
D5_3 n5_3 0 DMOD
Rh0_1 n0_1 n0_2 100
Rv0_7 n0_7 n1_7 100
Rh12_10 n12_10 n12_11 100
D4_10 n4_10 0 DMOD
Rv9_11 n9_11 n10_11 100
D9_9 n9_9 0 DMOD
Rh9_11 n9_11 n9_12 100
Rv2_1 n2_1 n3_1 100
Rh10_0 n10_0 n10_1 100
Rh5_8 n5_8 n5_9 100
D7_8 n7_8 0 DMOD
D8_11 n8_11 0 DMOD
Rh9_12 n9_12 n9_13 100
D0_5 n0_5 0 DMOD
D0_7 n0_7 0 DMOD
Rv2_9 n2_9 n3_9 100
D8_12 n8_12 0 DMOD
Rh12_7 n12_7 n12_8 100
D3_1 n3_1 0 DMOD
Rh10_8 n10_8 n10_9 100
Rv6_5 n6_5 n7_5 100
Rv9_4 n9_4 n10_4 100
D11_7 n11_7 0 DMOD
Rv12_12 n12_12 n13_12 100
Rv2_6 n2_6 n3_6 100
D14_11 n14_11 0 DMOD
D7_6 n7_6 0 DMOD
Rv6_3 n6_3 n7_3 100
Rh12_3 n12_3 n12_4 100
Rh0_10 n0_10 n0_11 100
Rv11_13 n11_13 n12_13 100
Rh9_6 n9_6 n9_7 100
Rh10_5 n10_5 n10_6 100
Rv0_0 n0_0 n1_0 100
Rv4_4 n4_4 n5_4 100
Rv14_7 n14_7 n15_7 100
D8_15 n8_15 0 DMOD
D13_6 n13_6 0 DMOD
Rv8_13 n8_13 n9_13 100
Rh9_1 n9_1 n9_2 100
Rh6_4 n6_4 n6_5 100
Rh9_0 n9_0 n9_1 100
Rv7_7 n7_7 n8_7 100
D10_1 n10_1 0 DMOD
D11_8 n11_8 0 DMOD
Rv13_2 n13_2 n14_2 100
D14_7 n14_7 0 DMOD
D2_12 n2_12 0 DMOD
Rh7_7 n7_7 n7_8 100
Rv1_12 n1_12 n2_12 100
Rv7_5 n7_5 n8_5 100
Rv12_5 n12_5 n13_5 100
Rv3_14 n3_14 n4_14 100
Rv12_8 n12_8 n13_8 100
Rv4_1 n4_1 n5_1 100
Rv0_10 n0_10 n1_10 100
D2_9 n2_9 0 DMOD
Rh4_13 n4_13 n4_14 100
Rv14_14 n14_14 n15_14 100
D9_12 n9_12 0 DMOD
D4_11 n4_11 0 DMOD
Rv14_3 n14_3 n15_3 100
Rv1_10 n1_10 n2_10 100
D3_10 n3_10 0 DMOD
Rv9_7 n9_7 n10_7 100
D4_13 n4_13 0 DMOD
Rh7_3 n7_3 n7_4 100
D6_15 n6_15 0 DMOD
Rv2_2 n2_2 n3_2 100
D14_10 n14_10 0 DMOD
Rv9_6 n9_6 n10_6 100
Rh4_0 n4_0 n4_1 100
Rh7_1 n7_1 n7_2 100
Rh5_2 n5_2 n5_3 100
Rh14_13 n14_13 n14_14 100
Rh4_12 n4_12 n4_13 100
Rh10_13 n10_13 n10_14 100
Rv13_5 n13_5 n14_5 100
Rv2_12 n2_12 n3_12 100
Rh0_8 n0_8 n0_9 100
Rv2_3 n2_3 n3_3 100
D13_0 n13_0 0 DMOD
Rv6_7 n6_7 n7_7 100
D5_11 n5_11 0 DMOD
D12_4 n12_4 0 DMOD
D6_12 n6_12 0 DMOD
Rv3_15 n3_15 n4_15 100
Rv7_13 n7_13 n8_13 100
Rv3_12 n3_12 n4_12 100
Rh6_14 n6_14 n6_15 100
D6_7 n6_7 0 DMOD
D9_14 n9_14 0 DMOD
Rv5_6 n5_6 n6_6 100
D15_13 n15_13 0 DMOD
Rh0_6 n0_6 n0_7 100
Rh1_4 n1_4 n1_5 100
Rv0_6 n0_6 n1_6 100
Rv10_9 n10_9 n11_9 100
D13_7 n13_7 0 DMOD
Rh14_1 n14_1 n14_2 100
D7_10 n7_10 0 DMOD
Rv10_1 n10_1 n11_1 100
D7_3 n7_3 0 DMOD
D1_4 n1_4 0 DMOD
Rh2_13 n2_13 n2_14 100
Rv12_15 n12_15 n13_15 100
Rh13_11 n13_11 n13_12 100
Rv6_12 n6_12 n7_12 100
D12_9 n12_9 0 DMOD
Rh13_10 n13_10 n13_11 100
D0_3 n0_3 0 DMOD
Rh13_1 n13_1 n13_2 100
D11_14 n11_14 0 DMOD
Rv6_8 n6_8 n7_8 100
Rv11_4 n11_4 n12_4 100
Rh14_8 n14_8 n14_9 100
Rh9_7 n9_7 n9_8 100
Rh14_7 n14_7 n14_8 100
D15_15 n15_15 0 DMOD
Rh9_5 n9_5 n9_6 100
Rh5_13 n5_13 n5_14 100
Rv14_6 n14_6 n15_6 100
D2_3 n2_3 0 DMOD
D12_2 n12_2 0 DMOD
Rh14_6 n14_6 n14_7 100
Rh11_4 n11_4 n11_5 100
Rv9_15 n9_15 n10_15 100
Rh8_2 n8_2 n8_3 100
Rh13_8 n13_8 n13_9 100
D2_15 n2_15 0 DMOD
Rh7_12 n7_12 n7_13 100
Rh6_12 n6_12 n6_13 100
Rh7_5 n7_5 n7_6 100
Rh14_14 n14_14 n14_15 100
Rh3_5 n3_5 n3_6 100
Rv5_10 n5_10 n6_10 100
Rv6_4 n6_4 n7_4 100
Rv14_4 n14_4 n15_4 100
D4_4 n4_4 0 DMOD
D0_10 n0_10 0 DMOD
Rv11_9 n11_9 n12_9 100
Rh13_0 n13_0 n13_1 100
Rv2_4 n2_4 n3_4 100
Rv1_9 n1_9 n2_9 100
Rv0_1 n0_1 n1_1 100
D6_11 n6_11 0 DMOD
Rv14_9 n14_9 n15_9 100
Rh5_1 n5_1 n5_2 100
D10_15 n10_15 0 DMOD
Rh6_0 n6_0 n6_1 100
D15_8 n15_8 0 DMOD
Rh7_2 n7_2 n7_3 100
Rh12_11 n12_11 n12_12 100
Rv8_2 n8_2 n9_2 100
Rv0_14 n0_14 n1_14 100
Rh13_5 n13_5 n13_6 100
D13_2 n13_2 0 DMOD
Rh0_14 n0_14 n0_15 100
Rh2_8 n2_8 n2_9 100
D9_0 n9_0 0 DMOD
D14_12 n14_12 0 DMOD
Rh6_5 n6_5 n6_6 100
D0_6 n0_6 0 DMOD
Rh15_3 n15_3 n15_4 100
D8_14 n8_14 0 DMOD
Rh1_6 n1_6 n1_7 100
D7_7 n7_7 0 DMOD
Rv1_13 n1_13 n2_13 100
Rv10_7 n10_7 n11_7 100
D10_7 n10_7 0 DMOD
D1_5 n1_5 0 DMOD
Rh2_10 n2_10 n2_11 100
Rh6_2 n6_2 n6_3 100
D5_12 n5_12 0 DMOD
D14_6 n14_6 0 DMOD
Rv13_11 n13_11 n14_11 100
Rv4_8 n4_8 n5_8 100
Rh2_3 n2_3 n2_4 100
Rh12_5 n12_5 n12_6 100
Rh12_6 n12_6 n12_7 100
Rv11_11 n11_11 n12_11 100
D7_1 n7_1 0 DMOD
D3_8 n3_8 0 DMOD
D15_10 n15_10 0 DMOD
Rv6_0 n6_0 n7_0 100
D0_9 n0_9 0 DMOD
Rh7_4 n7_4 n7_5 100
D15_3 n15_3 0 DMOD
Rv12_10 n12_10 n13_10 100
D8_13 n8_13 0 DMOD
D12_11 n12_11 0 DMOD
D11_9 n11_9 0 DMOD
Rh7_9 n7_9 n7_10 100
D12_7 n12_7 0 DMOD
Rv8_5 n8_5 n9_5 100
D11_0 n11_0 0 DMOD
D9_2 n9_2 0 DMOD
D14_14 n14_14 0 DMOD
Rh13_9 n13_9 n13_10 100
D9_7 n9_7 0 DMOD
D5_9 n5_9 0 DMOD
Rv4_10 n4_10 n5_10 100
Rh10_11 n10_11 n10_12 100
Rh2_14 n2_14 n2_15 100
Rh0_11 n0_11 n0_12 100
D2_1 n2_1 0 DMOD
Rh7_14 n7_14 n7_15 100
Rv2_13 n2_13 n3_13 100
D9_10 n9_10 0 DMOD
D12_8 n12_8 0 DMOD
Rv8_8 n8_8 n9_8 100
D9_4 n9_4 0 DMOD
D8_6 n8_6 0 DMOD
Rh12_14 n12_14 n12_15 100
D10_4 n10_4 0 DMOD
Rv5_12 n5_12 n6_12 100
Rv0_9 n0_9 n1_9 100
D6_8 n6_8 0 DMOD
Rv0_13 n0_13 n1_13 100
D12_13 n12_13 0 DMOD
Rv3_6 n3_6 n4_6 100
Rh1_5 n1_5 n1_6 100
D14_9 n14_9 0 DMOD
Rh0_4 n0_4 n0_5 100
D8_7 n8_7 0 DMOD
Rh11_5 n11_5 n11_6 100
D3_4 n3_4 0 DMOD
Rh13_12 n13_12 n13_13 100
D5_0 n5_0 0 DMOD
Rv3_3 n3_3 n4_3 100
Rv13_13 n13_13 n14_13 100
Rh8_9 n8_9 n8_10 100
D10_5 n10_5 0 DMOD
Rh11_14 n11_14 n11_15 100
Rh11_11 n11_11 n11_12 100
D10_3 n10_3 0 DMOD
D4_2 n4_2 0 DMOD
Rv5_0 n5_0 n6_0 100
D11_15 n11_15 0 DMOD
Rh5_9 n5_9 n5_10 100
Rv10_2 n10_2 n11_2 100
Rv0_3 n0_3 n1_3 100
Rh13_2 n13_2 n13_3 100
D1_6 n1_6 0 DMOD
Rh12_9 n12_9 n12_10 100
D13_9 n13_9 0 DMOD
Rh10_4 n10_4 n10_5 100
Rv13_1 n13_1 n14_1 100
D8_0 n8_0 0 DMOD
Rh2_12 n2_12 n2_13 100
Rv11_12 n11_12 n12_12 100
Rh12_13 n12_13 n12_14 100
D5_2 n5_2 0 DMOD
.dc V1 0 3 0.1
.end
