single voltage source with nothing attached
* bench.id: rob_hs_sing_single_vsource
* bench.group: robustness
* bench.title: single voltage source with nothing attached
* bench.probes: v(1), i(v1)
* bench.expect: match
* bench.tags: singular, dc, lenient_ok
* bench.est_rss_mib: 64
V1 1 0 5
.op
.end
