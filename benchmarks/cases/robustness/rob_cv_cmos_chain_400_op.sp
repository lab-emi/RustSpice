400-stage CMOS inverter chain, input at 0 V
* bench.id: rob_cv_cmos_chain_400_op
* bench.group: robustness
* bench.title: 400-stage CMOS inverter chain, input at 0 V
* bench.probes: v(n1), v(n2), v(n399), v(n400)
* bench.expect: match
* bench.size: 400
* bench.est_rss_mib: 32
* bench.tags: nonlinear, chain, homotopy, op
* bench.note: ngspice-47 solves with dynamic gmin stepping (16 ms). Sizing-dependent: the same chain with kp=100u/40u and W=2u/4u converges to 1000 stages, so the cliff is not a pure stage-count limit. Calibration evidence: ngspice returns the expected alternating rail pattern (every stage within 1e-9 V of 0 or 3.3 V, inverted at each stage, so n1 = 3.3 and n400 = 0 for an even chain with the input at 0 V); the engine's 150-iteration failure is therefore a convergence limit, not a different valid solution. Slug newton-iteration-cap (registered; not no-op-homotopy-tran, the .op already has homotopy): with max_iters = 1000 RustSpice gives n1 = 3.2999999989423077 V and n2 = 1.057692307637e-9 V, equal to an independent 1-D inverter-map chain oracle (3.2999999989423, 1.057692308e-9) and to tight ngspice within 3e-12 V.
.model NMOD NMOS(LEVEL=1 VTO=0.7 KP=120u LAMBDA=0.02)
.model PMOD PMOS(LEVEL=1 VTO=-0.7 KP=60u LAMBDA=0.02)
VDD vdd 0 DC 3.3
VIN in1 0 0
MP1 n1 in1 vdd vdd PMOD W=20u L=1u
MN1 n1 in1 0 0 NMOD W=10u L=1u
MP2 n2 n1 vdd vdd PMOD W=20u L=1u
MN2 n2 n1 0 0 NMOD W=10u L=1u
MP3 n3 n2 vdd vdd PMOD W=20u L=1u
MN3 n3 n2 0 0 NMOD W=10u L=1u
MP4 n4 n3 vdd vdd PMOD W=20u L=1u
MN4 n4 n3 0 0 NMOD W=10u L=1u
MP5 n5 n4 vdd vdd PMOD W=20u L=1u
MN5 n5 n4 0 0 NMOD W=10u L=1u
MP6 n6 n5 vdd vdd PMOD W=20u L=1u
MN6 n6 n5 0 0 NMOD W=10u L=1u
MP7 n7 n6 vdd vdd PMOD W=20u L=1u
MN7 n7 n6 0 0 NMOD W=10u L=1u
MP8 n8 n7 vdd vdd PMOD W=20u L=1u
MN8 n8 n7 0 0 NMOD W=10u L=1u
MP9 n9 n8 vdd vdd PMOD W=20u L=1u
MN9 n9 n8 0 0 NMOD W=10u L=1u
MP10 n10 n9 vdd vdd PMOD W=20u L=1u
MN10 n10 n9 0 0 NMOD W=10u L=1u
MP11 n11 n10 vdd vdd PMOD W=20u L=1u
MN11 n11 n10 0 0 NMOD W=10u L=1u
MP12 n12 n11 vdd vdd PMOD W=20u L=1u
MN12 n12 n11 0 0 NMOD W=10u L=1u
MP13 n13 n12 vdd vdd PMOD W=20u L=1u
MN13 n13 n12 0 0 NMOD W=10u L=1u
MP14 n14 n13 vdd vdd PMOD W=20u L=1u
MN14 n14 n13 0 0 NMOD W=10u L=1u
MP15 n15 n14 vdd vdd PMOD W=20u L=1u
MN15 n15 n14 0 0 NMOD W=10u L=1u
MP16 n16 n15 vdd vdd PMOD W=20u L=1u
MN16 n16 n15 0 0 NMOD W=10u L=1u
MP17 n17 n16 vdd vdd PMOD W=20u L=1u
MN17 n17 n16 0 0 NMOD W=10u L=1u
MP18 n18 n17 vdd vdd PMOD W=20u L=1u
MN18 n18 n17 0 0 NMOD W=10u L=1u
MP19 n19 n18 vdd vdd PMOD W=20u L=1u
MN19 n19 n18 0 0 NMOD W=10u L=1u
MP20 n20 n19 vdd vdd PMOD W=20u L=1u
MN20 n20 n19 0 0 NMOD W=10u L=1u
MP21 n21 n20 vdd vdd PMOD W=20u L=1u
MN21 n21 n20 0 0 NMOD W=10u L=1u
MP22 n22 n21 vdd vdd PMOD W=20u L=1u
MN22 n22 n21 0 0 NMOD W=10u L=1u
MP23 n23 n22 vdd vdd PMOD W=20u L=1u
MN23 n23 n22 0 0 NMOD W=10u L=1u
MP24 n24 n23 vdd vdd PMOD W=20u L=1u
MN24 n24 n23 0 0 NMOD W=10u L=1u
MP25 n25 n24 vdd vdd PMOD W=20u L=1u
MN25 n25 n24 0 0 NMOD W=10u L=1u
MP26 n26 n25 vdd vdd PMOD W=20u L=1u
MN26 n26 n25 0 0 NMOD W=10u L=1u
MP27 n27 n26 vdd vdd PMOD W=20u L=1u
MN27 n27 n26 0 0 NMOD W=10u L=1u
MP28 n28 n27 vdd vdd PMOD W=20u L=1u
MN28 n28 n27 0 0 NMOD W=10u L=1u
MP29 n29 n28 vdd vdd PMOD W=20u L=1u
MN29 n29 n28 0 0 NMOD W=10u L=1u
MP30 n30 n29 vdd vdd PMOD W=20u L=1u
MN30 n30 n29 0 0 NMOD W=10u L=1u
MP31 n31 n30 vdd vdd PMOD W=20u L=1u
MN31 n31 n30 0 0 NMOD W=10u L=1u
MP32 n32 n31 vdd vdd PMOD W=20u L=1u
MN32 n32 n31 0 0 NMOD W=10u L=1u
MP33 n33 n32 vdd vdd PMOD W=20u L=1u
MN33 n33 n32 0 0 NMOD W=10u L=1u
MP34 n34 n33 vdd vdd PMOD W=20u L=1u
MN34 n34 n33 0 0 NMOD W=10u L=1u
MP35 n35 n34 vdd vdd PMOD W=20u L=1u
MN35 n35 n34 0 0 NMOD W=10u L=1u
MP36 n36 n35 vdd vdd PMOD W=20u L=1u
MN36 n36 n35 0 0 NMOD W=10u L=1u
MP37 n37 n36 vdd vdd PMOD W=20u L=1u
MN37 n37 n36 0 0 NMOD W=10u L=1u
MP38 n38 n37 vdd vdd PMOD W=20u L=1u
MN38 n38 n37 0 0 NMOD W=10u L=1u
MP39 n39 n38 vdd vdd PMOD W=20u L=1u
MN39 n39 n38 0 0 NMOD W=10u L=1u
MP40 n40 n39 vdd vdd PMOD W=20u L=1u
MN40 n40 n39 0 0 NMOD W=10u L=1u
MP41 n41 n40 vdd vdd PMOD W=20u L=1u
MN41 n41 n40 0 0 NMOD W=10u L=1u
MP42 n42 n41 vdd vdd PMOD W=20u L=1u
MN42 n42 n41 0 0 NMOD W=10u L=1u
MP43 n43 n42 vdd vdd PMOD W=20u L=1u
MN43 n43 n42 0 0 NMOD W=10u L=1u
MP44 n44 n43 vdd vdd PMOD W=20u L=1u
MN44 n44 n43 0 0 NMOD W=10u L=1u
MP45 n45 n44 vdd vdd PMOD W=20u L=1u
MN45 n45 n44 0 0 NMOD W=10u L=1u
MP46 n46 n45 vdd vdd PMOD W=20u L=1u
MN46 n46 n45 0 0 NMOD W=10u L=1u
MP47 n47 n46 vdd vdd PMOD W=20u L=1u
MN47 n47 n46 0 0 NMOD W=10u L=1u
MP48 n48 n47 vdd vdd PMOD W=20u L=1u
MN48 n48 n47 0 0 NMOD W=10u L=1u
MP49 n49 n48 vdd vdd PMOD W=20u L=1u
MN49 n49 n48 0 0 NMOD W=10u L=1u
MP50 n50 n49 vdd vdd PMOD W=20u L=1u
MN50 n50 n49 0 0 NMOD W=10u L=1u
MP51 n51 n50 vdd vdd PMOD W=20u L=1u
MN51 n51 n50 0 0 NMOD W=10u L=1u
MP52 n52 n51 vdd vdd PMOD W=20u L=1u
MN52 n52 n51 0 0 NMOD W=10u L=1u
MP53 n53 n52 vdd vdd PMOD W=20u L=1u
MN53 n53 n52 0 0 NMOD W=10u L=1u
MP54 n54 n53 vdd vdd PMOD W=20u L=1u
MN54 n54 n53 0 0 NMOD W=10u L=1u
MP55 n55 n54 vdd vdd PMOD W=20u L=1u
MN55 n55 n54 0 0 NMOD W=10u L=1u
MP56 n56 n55 vdd vdd PMOD W=20u L=1u
MN56 n56 n55 0 0 NMOD W=10u L=1u
MP57 n57 n56 vdd vdd PMOD W=20u L=1u
MN57 n57 n56 0 0 NMOD W=10u L=1u
MP58 n58 n57 vdd vdd PMOD W=20u L=1u
MN58 n58 n57 0 0 NMOD W=10u L=1u
MP59 n59 n58 vdd vdd PMOD W=20u L=1u
MN59 n59 n58 0 0 NMOD W=10u L=1u
MP60 n60 n59 vdd vdd PMOD W=20u L=1u
MN60 n60 n59 0 0 NMOD W=10u L=1u
MP61 n61 n60 vdd vdd PMOD W=20u L=1u
MN61 n61 n60 0 0 NMOD W=10u L=1u
MP62 n62 n61 vdd vdd PMOD W=20u L=1u
MN62 n62 n61 0 0 NMOD W=10u L=1u
MP63 n63 n62 vdd vdd PMOD W=20u L=1u
MN63 n63 n62 0 0 NMOD W=10u L=1u
MP64 n64 n63 vdd vdd PMOD W=20u L=1u
MN64 n64 n63 0 0 NMOD W=10u L=1u
MP65 n65 n64 vdd vdd PMOD W=20u L=1u
MN65 n65 n64 0 0 NMOD W=10u L=1u
MP66 n66 n65 vdd vdd PMOD W=20u L=1u
MN66 n66 n65 0 0 NMOD W=10u L=1u
MP67 n67 n66 vdd vdd PMOD W=20u L=1u
MN67 n67 n66 0 0 NMOD W=10u L=1u
MP68 n68 n67 vdd vdd PMOD W=20u L=1u
MN68 n68 n67 0 0 NMOD W=10u L=1u
MP69 n69 n68 vdd vdd PMOD W=20u L=1u
MN69 n69 n68 0 0 NMOD W=10u L=1u
MP70 n70 n69 vdd vdd PMOD W=20u L=1u
MN70 n70 n69 0 0 NMOD W=10u L=1u
MP71 n71 n70 vdd vdd PMOD W=20u L=1u
MN71 n71 n70 0 0 NMOD W=10u L=1u
MP72 n72 n71 vdd vdd PMOD W=20u L=1u
MN72 n72 n71 0 0 NMOD W=10u L=1u
MP73 n73 n72 vdd vdd PMOD W=20u L=1u
MN73 n73 n72 0 0 NMOD W=10u L=1u
MP74 n74 n73 vdd vdd PMOD W=20u L=1u
MN74 n74 n73 0 0 NMOD W=10u L=1u
MP75 n75 n74 vdd vdd PMOD W=20u L=1u
MN75 n75 n74 0 0 NMOD W=10u L=1u
MP76 n76 n75 vdd vdd PMOD W=20u L=1u
MN76 n76 n75 0 0 NMOD W=10u L=1u
MP77 n77 n76 vdd vdd PMOD W=20u L=1u
MN77 n77 n76 0 0 NMOD W=10u L=1u
MP78 n78 n77 vdd vdd PMOD W=20u L=1u
MN78 n78 n77 0 0 NMOD W=10u L=1u
MP79 n79 n78 vdd vdd PMOD W=20u L=1u
MN79 n79 n78 0 0 NMOD W=10u L=1u
MP80 n80 n79 vdd vdd PMOD W=20u L=1u
MN80 n80 n79 0 0 NMOD W=10u L=1u
MP81 n81 n80 vdd vdd PMOD W=20u L=1u
MN81 n81 n80 0 0 NMOD W=10u L=1u
MP82 n82 n81 vdd vdd PMOD W=20u L=1u
MN82 n82 n81 0 0 NMOD W=10u L=1u
MP83 n83 n82 vdd vdd PMOD W=20u L=1u
MN83 n83 n82 0 0 NMOD W=10u L=1u
MP84 n84 n83 vdd vdd PMOD W=20u L=1u
MN84 n84 n83 0 0 NMOD W=10u L=1u
MP85 n85 n84 vdd vdd PMOD W=20u L=1u
MN85 n85 n84 0 0 NMOD W=10u L=1u
MP86 n86 n85 vdd vdd PMOD W=20u L=1u
MN86 n86 n85 0 0 NMOD W=10u L=1u
MP87 n87 n86 vdd vdd PMOD W=20u L=1u
MN87 n87 n86 0 0 NMOD W=10u L=1u
MP88 n88 n87 vdd vdd PMOD W=20u L=1u
MN88 n88 n87 0 0 NMOD W=10u L=1u
MP89 n89 n88 vdd vdd PMOD W=20u L=1u
MN89 n89 n88 0 0 NMOD W=10u L=1u
MP90 n90 n89 vdd vdd PMOD W=20u L=1u
MN90 n90 n89 0 0 NMOD W=10u L=1u
MP91 n91 n90 vdd vdd PMOD W=20u L=1u
MN91 n91 n90 0 0 NMOD W=10u L=1u
MP92 n92 n91 vdd vdd PMOD W=20u L=1u
MN92 n92 n91 0 0 NMOD W=10u L=1u
MP93 n93 n92 vdd vdd PMOD W=20u L=1u
MN93 n93 n92 0 0 NMOD W=10u L=1u
MP94 n94 n93 vdd vdd PMOD W=20u L=1u
MN94 n94 n93 0 0 NMOD W=10u L=1u
MP95 n95 n94 vdd vdd PMOD W=20u L=1u
MN95 n95 n94 0 0 NMOD W=10u L=1u
MP96 n96 n95 vdd vdd PMOD W=20u L=1u
MN96 n96 n95 0 0 NMOD W=10u L=1u
MP97 n97 n96 vdd vdd PMOD W=20u L=1u
MN97 n97 n96 0 0 NMOD W=10u L=1u
MP98 n98 n97 vdd vdd PMOD W=20u L=1u
MN98 n98 n97 0 0 NMOD W=10u L=1u
MP99 n99 n98 vdd vdd PMOD W=20u L=1u
MN99 n99 n98 0 0 NMOD W=10u L=1u
MP100 n100 n99 vdd vdd PMOD W=20u L=1u
MN100 n100 n99 0 0 NMOD W=10u L=1u
MP101 n101 n100 vdd vdd PMOD W=20u L=1u
MN101 n101 n100 0 0 NMOD W=10u L=1u
MP102 n102 n101 vdd vdd PMOD W=20u L=1u
MN102 n102 n101 0 0 NMOD W=10u L=1u
MP103 n103 n102 vdd vdd PMOD W=20u L=1u
MN103 n103 n102 0 0 NMOD W=10u L=1u
MP104 n104 n103 vdd vdd PMOD W=20u L=1u
MN104 n104 n103 0 0 NMOD W=10u L=1u
MP105 n105 n104 vdd vdd PMOD W=20u L=1u
MN105 n105 n104 0 0 NMOD W=10u L=1u
MP106 n106 n105 vdd vdd PMOD W=20u L=1u
MN106 n106 n105 0 0 NMOD W=10u L=1u
MP107 n107 n106 vdd vdd PMOD W=20u L=1u
MN107 n107 n106 0 0 NMOD W=10u L=1u
MP108 n108 n107 vdd vdd PMOD W=20u L=1u
MN108 n108 n107 0 0 NMOD W=10u L=1u
MP109 n109 n108 vdd vdd PMOD W=20u L=1u
MN109 n109 n108 0 0 NMOD W=10u L=1u
MP110 n110 n109 vdd vdd PMOD W=20u L=1u
MN110 n110 n109 0 0 NMOD W=10u L=1u
MP111 n111 n110 vdd vdd PMOD W=20u L=1u
MN111 n111 n110 0 0 NMOD W=10u L=1u
MP112 n112 n111 vdd vdd PMOD W=20u L=1u
MN112 n112 n111 0 0 NMOD W=10u L=1u
MP113 n113 n112 vdd vdd PMOD W=20u L=1u
MN113 n113 n112 0 0 NMOD W=10u L=1u
MP114 n114 n113 vdd vdd PMOD W=20u L=1u
MN114 n114 n113 0 0 NMOD W=10u L=1u
MP115 n115 n114 vdd vdd PMOD W=20u L=1u
MN115 n115 n114 0 0 NMOD W=10u L=1u
MP116 n116 n115 vdd vdd PMOD W=20u L=1u
MN116 n116 n115 0 0 NMOD W=10u L=1u
MP117 n117 n116 vdd vdd PMOD W=20u L=1u
MN117 n117 n116 0 0 NMOD W=10u L=1u
MP118 n118 n117 vdd vdd PMOD W=20u L=1u
MN118 n118 n117 0 0 NMOD W=10u L=1u
MP119 n119 n118 vdd vdd PMOD W=20u L=1u
MN119 n119 n118 0 0 NMOD W=10u L=1u
MP120 n120 n119 vdd vdd PMOD W=20u L=1u
MN120 n120 n119 0 0 NMOD W=10u L=1u
MP121 n121 n120 vdd vdd PMOD W=20u L=1u
MN121 n121 n120 0 0 NMOD W=10u L=1u
MP122 n122 n121 vdd vdd PMOD W=20u L=1u
MN122 n122 n121 0 0 NMOD W=10u L=1u
MP123 n123 n122 vdd vdd PMOD W=20u L=1u
MN123 n123 n122 0 0 NMOD W=10u L=1u
MP124 n124 n123 vdd vdd PMOD W=20u L=1u
MN124 n124 n123 0 0 NMOD W=10u L=1u
MP125 n125 n124 vdd vdd PMOD W=20u L=1u
MN125 n125 n124 0 0 NMOD W=10u L=1u
MP126 n126 n125 vdd vdd PMOD W=20u L=1u
MN126 n126 n125 0 0 NMOD W=10u L=1u
MP127 n127 n126 vdd vdd PMOD W=20u L=1u
MN127 n127 n126 0 0 NMOD W=10u L=1u
MP128 n128 n127 vdd vdd PMOD W=20u L=1u
MN128 n128 n127 0 0 NMOD W=10u L=1u
MP129 n129 n128 vdd vdd PMOD W=20u L=1u
MN129 n129 n128 0 0 NMOD W=10u L=1u
MP130 n130 n129 vdd vdd PMOD W=20u L=1u
MN130 n130 n129 0 0 NMOD W=10u L=1u
MP131 n131 n130 vdd vdd PMOD W=20u L=1u
MN131 n131 n130 0 0 NMOD W=10u L=1u
MP132 n132 n131 vdd vdd PMOD W=20u L=1u
MN132 n132 n131 0 0 NMOD W=10u L=1u
MP133 n133 n132 vdd vdd PMOD W=20u L=1u
MN133 n133 n132 0 0 NMOD W=10u L=1u
MP134 n134 n133 vdd vdd PMOD W=20u L=1u
MN134 n134 n133 0 0 NMOD W=10u L=1u
MP135 n135 n134 vdd vdd PMOD W=20u L=1u
MN135 n135 n134 0 0 NMOD W=10u L=1u
MP136 n136 n135 vdd vdd PMOD W=20u L=1u
MN136 n136 n135 0 0 NMOD W=10u L=1u
MP137 n137 n136 vdd vdd PMOD W=20u L=1u
MN137 n137 n136 0 0 NMOD W=10u L=1u
MP138 n138 n137 vdd vdd PMOD W=20u L=1u
MN138 n138 n137 0 0 NMOD W=10u L=1u
MP139 n139 n138 vdd vdd PMOD W=20u L=1u
MN139 n139 n138 0 0 NMOD W=10u L=1u
MP140 n140 n139 vdd vdd PMOD W=20u L=1u
MN140 n140 n139 0 0 NMOD W=10u L=1u
MP141 n141 n140 vdd vdd PMOD W=20u L=1u
MN141 n141 n140 0 0 NMOD W=10u L=1u
MP142 n142 n141 vdd vdd PMOD W=20u L=1u
MN142 n142 n141 0 0 NMOD W=10u L=1u
MP143 n143 n142 vdd vdd PMOD W=20u L=1u
MN143 n143 n142 0 0 NMOD W=10u L=1u
MP144 n144 n143 vdd vdd PMOD W=20u L=1u
MN144 n144 n143 0 0 NMOD W=10u L=1u
MP145 n145 n144 vdd vdd PMOD W=20u L=1u
MN145 n145 n144 0 0 NMOD W=10u L=1u
MP146 n146 n145 vdd vdd PMOD W=20u L=1u
MN146 n146 n145 0 0 NMOD W=10u L=1u
MP147 n147 n146 vdd vdd PMOD W=20u L=1u
MN147 n147 n146 0 0 NMOD W=10u L=1u
MP148 n148 n147 vdd vdd PMOD W=20u L=1u
MN148 n148 n147 0 0 NMOD W=10u L=1u
MP149 n149 n148 vdd vdd PMOD W=20u L=1u
MN149 n149 n148 0 0 NMOD W=10u L=1u
MP150 n150 n149 vdd vdd PMOD W=20u L=1u
MN150 n150 n149 0 0 NMOD W=10u L=1u
MP151 n151 n150 vdd vdd PMOD W=20u L=1u
MN151 n151 n150 0 0 NMOD W=10u L=1u
MP152 n152 n151 vdd vdd PMOD W=20u L=1u
MN152 n152 n151 0 0 NMOD W=10u L=1u
MP153 n153 n152 vdd vdd PMOD W=20u L=1u
MN153 n153 n152 0 0 NMOD W=10u L=1u
MP154 n154 n153 vdd vdd PMOD W=20u L=1u
MN154 n154 n153 0 0 NMOD W=10u L=1u
MP155 n155 n154 vdd vdd PMOD W=20u L=1u
MN155 n155 n154 0 0 NMOD W=10u L=1u
MP156 n156 n155 vdd vdd PMOD W=20u L=1u
MN156 n156 n155 0 0 NMOD W=10u L=1u
MP157 n157 n156 vdd vdd PMOD W=20u L=1u
MN157 n157 n156 0 0 NMOD W=10u L=1u
MP158 n158 n157 vdd vdd PMOD W=20u L=1u
MN158 n158 n157 0 0 NMOD W=10u L=1u
MP159 n159 n158 vdd vdd PMOD W=20u L=1u
MN159 n159 n158 0 0 NMOD W=10u L=1u
MP160 n160 n159 vdd vdd PMOD W=20u L=1u
MN160 n160 n159 0 0 NMOD W=10u L=1u
MP161 n161 n160 vdd vdd PMOD W=20u L=1u
MN161 n161 n160 0 0 NMOD W=10u L=1u
MP162 n162 n161 vdd vdd PMOD W=20u L=1u
MN162 n162 n161 0 0 NMOD W=10u L=1u
MP163 n163 n162 vdd vdd PMOD W=20u L=1u
MN163 n163 n162 0 0 NMOD W=10u L=1u
MP164 n164 n163 vdd vdd PMOD W=20u L=1u
MN164 n164 n163 0 0 NMOD W=10u L=1u
MP165 n165 n164 vdd vdd PMOD W=20u L=1u
MN165 n165 n164 0 0 NMOD W=10u L=1u
MP166 n166 n165 vdd vdd PMOD W=20u L=1u
MN166 n166 n165 0 0 NMOD W=10u L=1u
MP167 n167 n166 vdd vdd PMOD W=20u L=1u
MN167 n167 n166 0 0 NMOD W=10u L=1u
MP168 n168 n167 vdd vdd PMOD W=20u L=1u
MN168 n168 n167 0 0 NMOD W=10u L=1u
MP169 n169 n168 vdd vdd PMOD W=20u L=1u
MN169 n169 n168 0 0 NMOD W=10u L=1u
MP170 n170 n169 vdd vdd PMOD W=20u L=1u
MN170 n170 n169 0 0 NMOD W=10u L=1u
MP171 n171 n170 vdd vdd PMOD W=20u L=1u
MN171 n171 n170 0 0 NMOD W=10u L=1u
MP172 n172 n171 vdd vdd PMOD W=20u L=1u
MN172 n172 n171 0 0 NMOD W=10u L=1u
MP173 n173 n172 vdd vdd PMOD W=20u L=1u
MN173 n173 n172 0 0 NMOD W=10u L=1u
MP174 n174 n173 vdd vdd PMOD W=20u L=1u
MN174 n174 n173 0 0 NMOD W=10u L=1u
MP175 n175 n174 vdd vdd PMOD W=20u L=1u
MN175 n175 n174 0 0 NMOD W=10u L=1u
MP176 n176 n175 vdd vdd PMOD W=20u L=1u
MN176 n176 n175 0 0 NMOD W=10u L=1u
MP177 n177 n176 vdd vdd PMOD W=20u L=1u
MN177 n177 n176 0 0 NMOD W=10u L=1u
MP178 n178 n177 vdd vdd PMOD W=20u L=1u
MN178 n178 n177 0 0 NMOD W=10u L=1u
MP179 n179 n178 vdd vdd PMOD W=20u L=1u
MN179 n179 n178 0 0 NMOD W=10u L=1u
MP180 n180 n179 vdd vdd PMOD W=20u L=1u
MN180 n180 n179 0 0 NMOD W=10u L=1u
MP181 n181 n180 vdd vdd PMOD W=20u L=1u
MN181 n181 n180 0 0 NMOD W=10u L=1u
MP182 n182 n181 vdd vdd PMOD W=20u L=1u
MN182 n182 n181 0 0 NMOD W=10u L=1u
MP183 n183 n182 vdd vdd PMOD W=20u L=1u
MN183 n183 n182 0 0 NMOD W=10u L=1u
MP184 n184 n183 vdd vdd PMOD W=20u L=1u
MN184 n184 n183 0 0 NMOD W=10u L=1u
MP185 n185 n184 vdd vdd PMOD W=20u L=1u
MN185 n185 n184 0 0 NMOD W=10u L=1u
MP186 n186 n185 vdd vdd PMOD W=20u L=1u
MN186 n186 n185 0 0 NMOD W=10u L=1u
MP187 n187 n186 vdd vdd PMOD W=20u L=1u
MN187 n187 n186 0 0 NMOD W=10u L=1u
MP188 n188 n187 vdd vdd PMOD W=20u L=1u
MN188 n188 n187 0 0 NMOD W=10u L=1u
MP189 n189 n188 vdd vdd PMOD W=20u L=1u
MN189 n189 n188 0 0 NMOD W=10u L=1u
MP190 n190 n189 vdd vdd PMOD W=20u L=1u
MN190 n190 n189 0 0 NMOD W=10u L=1u
MP191 n191 n190 vdd vdd PMOD W=20u L=1u
MN191 n191 n190 0 0 NMOD W=10u L=1u
MP192 n192 n191 vdd vdd PMOD W=20u L=1u
MN192 n192 n191 0 0 NMOD W=10u L=1u
MP193 n193 n192 vdd vdd PMOD W=20u L=1u
MN193 n193 n192 0 0 NMOD W=10u L=1u
MP194 n194 n193 vdd vdd PMOD W=20u L=1u
MN194 n194 n193 0 0 NMOD W=10u L=1u
MP195 n195 n194 vdd vdd PMOD W=20u L=1u
MN195 n195 n194 0 0 NMOD W=10u L=1u
MP196 n196 n195 vdd vdd PMOD W=20u L=1u
MN196 n196 n195 0 0 NMOD W=10u L=1u
MP197 n197 n196 vdd vdd PMOD W=20u L=1u
MN197 n197 n196 0 0 NMOD W=10u L=1u
MP198 n198 n197 vdd vdd PMOD W=20u L=1u
MN198 n198 n197 0 0 NMOD W=10u L=1u
MP199 n199 n198 vdd vdd PMOD W=20u L=1u
MN199 n199 n198 0 0 NMOD W=10u L=1u
MP200 n200 n199 vdd vdd PMOD W=20u L=1u
MN200 n200 n199 0 0 NMOD W=10u L=1u
MP201 n201 n200 vdd vdd PMOD W=20u L=1u
MN201 n201 n200 0 0 NMOD W=10u L=1u
MP202 n202 n201 vdd vdd PMOD W=20u L=1u
MN202 n202 n201 0 0 NMOD W=10u L=1u
MP203 n203 n202 vdd vdd PMOD W=20u L=1u
MN203 n203 n202 0 0 NMOD W=10u L=1u
MP204 n204 n203 vdd vdd PMOD W=20u L=1u
MN204 n204 n203 0 0 NMOD W=10u L=1u
MP205 n205 n204 vdd vdd PMOD W=20u L=1u
MN205 n205 n204 0 0 NMOD W=10u L=1u
MP206 n206 n205 vdd vdd PMOD W=20u L=1u
MN206 n206 n205 0 0 NMOD W=10u L=1u
MP207 n207 n206 vdd vdd PMOD W=20u L=1u
MN207 n207 n206 0 0 NMOD W=10u L=1u
MP208 n208 n207 vdd vdd PMOD W=20u L=1u
MN208 n208 n207 0 0 NMOD W=10u L=1u
MP209 n209 n208 vdd vdd PMOD W=20u L=1u
MN209 n209 n208 0 0 NMOD W=10u L=1u
MP210 n210 n209 vdd vdd PMOD W=20u L=1u
MN210 n210 n209 0 0 NMOD W=10u L=1u
MP211 n211 n210 vdd vdd PMOD W=20u L=1u
MN211 n211 n210 0 0 NMOD W=10u L=1u
MP212 n212 n211 vdd vdd PMOD W=20u L=1u
MN212 n212 n211 0 0 NMOD W=10u L=1u
MP213 n213 n212 vdd vdd PMOD W=20u L=1u
MN213 n213 n212 0 0 NMOD W=10u L=1u
MP214 n214 n213 vdd vdd PMOD W=20u L=1u
MN214 n214 n213 0 0 NMOD W=10u L=1u
MP215 n215 n214 vdd vdd PMOD W=20u L=1u
MN215 n215 n214 0 0 NMOD W=10u L=1u
MP216 n216 n215 vdd vdd PMOD W=20u L=1u
MN216 n216 n215 0 0 NMOD W=10u L=1u
MP217 n217 n216 vdd vdd PMOD W=20u L=1u
MN217 n217 n216 0 0 NMOD W=10u L=1u
MP218 n218 n217 vdd vdd PMOD W=20u L=1u
MN218 n218 n217 0 0 NMOD W=10u L=1u
MP219 n219 n218 vdd vdd PMOD W=20u L=1u
MN219 n219 n218 0 0 NMOD W=10u L=1u
MP220 n220 n219 vdd vdd PMOD W=20u L=1u
MN220 n220 n219 0 0 NMOD W=10u L=1u
MP221 n221 n220 vdd vdd PMOD W=20u L=1u
MN221 n221 n220 0 0 NMOD W=10u L=1u
MP222 n222 n221 vdd vdd PMOD W=20u L=1u
MN222 n222 n221 0 0 NMOD W=10u L=1u
MP223 n223 n222 vdd vdd PMOD W=20u L=1u
MN223 n223 n222 0 0 NMOD W=10u L=1u
MP224 n224 n223 vdd vdd PMOD W=20u L=1u
MN224 n224 n223 0 0 NMOD W=10u L=1u
MP225 n225 n224 vdd vdd PMOD W=20u L=1u
MN225 n225 n224 0 0 NMOD W=10u L=1u
MP226 n226 n225 vdd vdd PMOD W=20u L=1u
MN226 n226 n225 0 0 NMOD W=10u L=1u
MP227 n227 n226 vdd vdd PMOD W=20u L=1u
MN227 n227 n226 0 0 NMOD W=10u L=1u
MP228 n228 n227 vdd vdd PMOD W=20u L=1u
MN228 n228 n227 0 0 NMOD W=10u L=1u
MP229 n229 n228 vdd vdd PMOD W=20u L=1u
MN229 n229 n228 0 0 NMOD W=10u L=1u
MP230 n230 n229 vdd vdd PMOD W=20u L=1u
MN230 n230 n229 0 0 NMOD W=10u L=1u
MP231 n231 n230 vdd vdd PMOD W=20u L=1u
MN231 n231 n230 0 0 NMOD W=10u L=1u
MP232 n232 n231 vdd vdd PMOD W=20u L=1u
MN232 n232 n231 0 0 NMOD W=10u L=1u
MP233 n233 n232 vdd vdd PMOD W=20u L=1u
MN233 n233 n232 0 0 NMOD W=10u L=1u
MP234 n234 n233 vdd vdd PMOD W=20u L=1u
MN234 n234 n233 0 0 NMOD W=10u L=1u
MP235 n235 n234 vdd vdd PMOD W=20u L=1u
MN235 n235 n234 0 0 NMOD W=10u L=1u
MP236 n236 n235 vdd vdd PMOD W=20u L=1u
MN236 n236 n235 0 0 NMOD W=10u L=1u
MP237 n237 n236 vdd vdd PMOD W=20u L=1u
MN237 n237 n236 0 0 NMOD W=10u L=1u
MP238 n238 n237 vdd vdd PMOD W=20u L=1u
MN238 n238 n237 0 0 NMOD W=10u L=1u
MP239 n239 n238 vdd vdd PMOD W=20u L=1u
MN239 n239 n238 0 0 NMOD W=10u L=1u
MP240 n240 n239 vdd vdd PMOD W=20u L=1u
MN240 n240 n239 0 0 NMOD W=10u L=1u
MP241 n241 n240 vdd vdd PMOD W=20u L=1u
MN241 n241 n240 0 0 NMOD W=10u L=1u
MP242 n242 n241 vdd vdd PMOD W=20u L=1u
MN242 n242 n241 0 0 NMOD W=10u L=1u
MP243 n243 n242 vdd vdd PMOD W=20u L=1u
MN243 n243 n242 0 0 NMOD W=10u L=1u
MP244 n244 n243 vdd vdd PMOD W=20u L=1u
MN244 n244 n243 0 0 NMOD W=10u L=1u
MP245 n245 n244 vdd vdd PMOD W=20u L=1u
MN245 n245 n244 0 0 NMOD W=10u L=1u
MP246 n246 n245 vdd vdd PMOD W=20u L=1u
MN246 n246 n245 0 0 NMOD W=10u L=1u
MP247 n247 n246 vdd vdd PMOD W=20u L=1u
MN247 n247 n246 0 0 NMOD W=10u L=1u
MP248 n248 n247 vdd vdd PMOD W=20u L=1u
MN248 n248 n247 0 0 NMOD W=10u L=1u
MP249 n249 n248 vdd vdd PMOD W=20u L=1u
MN249 n249 n248 0 0 NMOD W=10u L=1u
MP250 n250 n249 vdd vdd PMOD W=20u L=1u
MN250 n250 n249 0 0 NMOD W=10u L=1u
MP251 n251 n250 vdd vdd PMOD W=20u L=1u
MN251 n251 n250 0 0 NMOD W=10u L=1u
MP252 n252 n251 vdd vdd PMOD W=20u L=1u
MN252 n252 n251 0 0 NMOD W=10u L=1u
MP253 n253 n252 vdd vdd PMOD W=20u L=1u
MN253 n253 n252 0 0 NMOD W=10u L=1u
MP254 n254 n253 vdd vdd PMOD W=20u L=1u
MN254 n254 n253 0 0 NMOD W=10u L=1u
MP255 n255 n254 vdd vdd PMOD W=20u L=1u
MN255 n255 n254 0 0 NMOD W=10u L=1u
MP256 n256 n255 vdd vdd PMOD W=20u L=1u
MN256 n256 n255 0 0 NMOD W=10u L=1u
MP257 n257 n256 vdd vdd PMOD W=20u L=1u
MN257 n257 n256 0 0 NMOD W=10u L=1u
MP258 n258 n257 vdd vdd PMOD W=20u L=1u
MN258 n258 n257 0 0 NMOD W=10u L=1u
MP259 n259 n258 vdd vdd PMOD W=20u L=1u
MN259 n259 n258 0 0 NMOD W=10u L=1u
MP260 n260 n259 vdd vdd PMOD W=20u L=1u
MN260 n260 n259 0 0 NMOD W=10u L=1u
MP261 n261 n260 vdd vdd PMOD W=20u L=1u
MN261 n261 n260 0 0 NMOD W=10u L=1u
MP262 n262 n261 vdd vdd PMOD W=20u L=1u
MN262 n262 n261 0 0 NMOD W=10u L=1u
MP263 n263 n262 vdd vdd PMOD W=20u L=1u
MN263 n263 n262 0 0 NMOD W=10u L=1u
MP264 n264 n263 vdd vdd PMOD W=20u L=1u
MN264 n264 n263 0 0 NMOD W=10u L=1u
MP265 n265 n264 vdd vdd PMOD W=20u L=1u
MN265 n265 n264 0 0 NMOD W=10u L=1u
MP266 n266 n265 vdd vdd PMOD W=20u L=1u
MN266 n266 n265 0 0 NMOD W=10u L=1u
MP267 n267 n266 vdd vdd PMOD W=20u L=1u
MN267 n267 n266 0 0 NMOD W=10u L=1u
MP268 n268 n267 vdd vdd PMOD W=20u L=1u
MN268 n268 n267 0 0 NMOD W=10u L=1u
MP269 n269 n268 vdd vdd PMOD W=20u L=1u
MN269 n269 n268 0 0 NMOD W=10u L=1u
MP270 n270 n269 vdd vdd PMOD W=20u L=1u
MN270 n270 n269 0 0 NMOD W=10u L=1u
MP271 n271 n270 vdd vdd PMOD W=20u L=1u
MN271 n271 n270 0 0 NMOD W=10u L=1u
MP272 n272 n271 vdd vdd PMOD W=20u L=1u
MN272 n272 n271 0 0 NMOD W=10u L=1u
MP273 n273 n272 vdd vdd PMOD W=20u L=1u
MN273 n273 n272 0 0 NMOD W=10u L=1u
MP274 n274 n273 vdd vdd PMOD W=20u L=1u
MN274 n274 n273 0 0 NMOD W=10u L=1u
MP275 n275 n274 vdd vdd PMOD W=20u L=1u
MN275 n275 n274 0 0 NMOD W=10u L=1u
MP276 n276 n275 vdd vdd PMOD W=20u L=1u
MN276 n276 n275 0 0 NMOD W=10u L=1u
MP277 n277 n276 vdd vdd PMOD W=20u L=1u
MN277 n277 n276 0 0 NMOD W=10u L=1u
MP278 n278 n277 vdd vdd PMOD W=20u L=1u
MN278 n278 n277 0 0 NMOD W=10u L=1u
MP279 n279 n278 vdd vdd PMOD W=20u L=1u
MN279 n279 n278 0 0 NMOD W=10u L=1u
MP280 n280 n279 vdd vdd PMOD W=20u L=1u
MN280 n280 n279 0 0 NMOD W=10u L=1u
MP281 n281 n280 vdd vdd PMOD W=20u L=1u
MN281 n281 n280 0 0 NMOD W=10u L=1u
MP282 n282 n281 vdd vdd PMOD W=20u L=1u
MN282 n282 n281 0 0 NMOD W=10u L=1u
MP283 n283 n282 vdd vdd PMOD W=20u L=1u
MN283 n283 n282 0 0 NMOD W=10u L=1u
MP284 n284 n283 vdd vdd PMOD W=20u L=1u
MN284 n284 n283 0 0 NMOD W=10u L=1u
MP285 n285 n284 vdd vdd PMOD W=20u L=1u
MN285 n285 n284 0 0 NMOD W=10u L=1u
MP286 n286 n285 vdd vdd PMOD W=20u L=1u
MN286 n286 n285 0 0 NMOD W=10u L=1u
MP287 n287 n286 vdd vdd PMOD W=20u L=1u
MN287 n287 n286 0 0 NMOD W=10u L=1u
MP288 n288 n287 vdd vdd PMOD W=20u L=1u
MN288 n288 n287 0 0 NMOD W=10u L=1u
MP289 n289 n288 vdd vdd PMOD W=20u L=1u
MN289 n289 n288 0 0 NMOD W=10u L=1u
MP290 n290 n289 vdd vdd PMOD W=20u L=1u
MN290 n290 n289 0 0 NMOD W=10u L=1u
MP291 n291 n290 vdd vdd PMOD W=20u L=1u
MN291 n291 n290 0 0 NMOD W=10u L=1u
MP292 n292 n291 vdd vdd PMOD W=20u L=1u
MN292 n292 n291 0 0 NMOD W=10u L=1u
MP293 n293 n292 vdd vdd PMOD W=20u L=1u
MN293 n293 n292 0 0 NMOD W=10u L=1u
MP294 n294 n293 vdd vdd PMOD W=20u L=1u
MN294 n294 n293 0 0 NMOD W=10u L=1u
MP295 n295 n294 vdd vdd PMOD W=20u L=1u
MN295 n295 n294 0 0 NMOD W=10u L=1u
MP296 n296 n295 vdd vdd PMOD W=20u L=1u
MN296 n296 n295 0 0 NMOD W=10u L=1u
MP297 n297 n296 vdd vdd PMOD W=20u L=1u
MN297 n297 n296 0 0 NMOD W=10u L=1u
MP298 n298 n297 vdd vdd PMOD W=20u L=1u
MN298 n298 n297 0 0 NMOD W=10u L=1u
MP299 n299 n298 vdd vdd PMOD W=20u L=1u
MN299 n299 n298 0 0 NMOD W=10u L=1u
MP300 n300 n299 vdd vdd PMOD W=20u L=1u
MN300 n300 n299 0 0 NMOD W=10u L=1u
MP301 n301 n300 vdd vdd PMOD W=20u L=1u
MN301 n301 n300 0 0 NMOD W=10u L=1u
MP302 n302 n301 vdd vdd PMOD W=20u L=1u
MN302 n302 n301 0 0 NMOD W=10u L=1u
MP303 n303 n302 vdd vdd PMOD W=20u L=1u
MN303 n303 n302 0 0 NMOD W=10u L=1u
MP304 n304 n303 vdd vdd PMOD W=20u L=1u
MN304 n304 n303 0 0 NMOD W=10u L=1u
MP305 n305 n304 vdd vdd PMOD W=20u L=1u
MN305 n305 n304 0 0 NMOD W=10u L=1u
MP306 n306 n305 vdd vdd PMOD W=20u L=1u
MN306 n306 n305 0 0 NMOD W=10u L=1u
MP307 n307 n306 vdd vdd PMOD W=20u L=1u
MN307 n307 n306 0 0 NMOD W=10u L=1u
MP308 n308 n307 vdd vdd PMOD W=20u L=1u
MN308 n308 n307 0 0 NMOD W=10u L=1u
MP309 n309 n308 vdd vdd PMOD W=20u L=1u
MN309 n309 n308 0 0 NMOD W=10u L=1u
MP310 n310 n309 vdd vdd PMOD W=20u L=1u
MN310 n310 n309 0 0 NMOD W=10u L=1u
MP311 n311 n310 vdd vdd PMOD W=20u L=1u
MN311 n311 n310 0 0 NMOD W=10u L=1u
MP312 n312 n311 vdd vdd PMOD W=20u L=1u
MN312 n312 n311 0 0 NMOD W=10u L=1u
MP313 n313 n312 vdd vdd PMOD W=20u L=1u
MN313 n313 n312 0 0 NMOD W=10u L=1u
MP314 n314 n313 vdd vdd PMOD W=20u L=1u
MN314 n314 n313 0 0 NMOD W=10u L=1u
MP315 n315 n314 vdd vdd PMOD W=20u L=1u
MN315 n315 n314 0 0 NMOD W=10u L=1u
MP316 n316 n315 vdd vdd PMOD W=20u L=1u
MN316 n316 n315 0 0 NMOD W=10u L=1u
MP317 n317 n316 vdd vdd PMOD W=20u L=1u
MN317 n317 n316 0 0 NMOD W=10u L=1u
MP318 n318 n317 vdd vdd PMOD W=20u L=1u
MN318 n318 n317 0 0 NMOD W=10u L=1u
MP319 n319 n318 vdd vdd PMOD W=20u L=1u
MN319 n319 n318 0 0 NMOD W=10u L=1u
MP320 n320 n319 vdd vdd PMOD W=20u L=1u
MN320 n320 n319 0 0 NMOD W=10u L=1u
MP321 n321 n320 vdd vdd PMOD W=20u L=1u
MN321 n321 n320 0 0 NMOD W=10u L=1u
MP322 n322 n321 vdd vdd PMOD W=20u L=1u
MN322 n322 n321 0 0 NMOD W=10u L=1u
MP323 n323 n322 vdd vdd PMOD W=20u L=1u
MN323 n323 n322 0 0 NMOD W=10u L=1u
MP324 n324 n323 vdd vdd PMOD W=20u L=1u
MN324 n324 n323 0 0 NMOD W=10u L=1u
MP325 n325 n324 vdd vdd PMOD W=20u L=1u
MN325 n325 n324 0 0 NMOD W=10u L=1u
MP326 n326 n325 vdd vdd PMOD W=20u L=1u
MN326 n326 n325 0 0 NMOD W=10u L=1u
MP327 n327 n326 vdd vdd PMOD W=20u L=1u
MN327 n327 n326 0 0 NMOD W=10u L=1u
MP328 n328 n327 vdd vdd PMOD W=20u L=1u
MN328 n328 n327 0 0 NMOD W=10u L=1u
MP329 n329 n328 vdd vdd PMOD W=20u L=1u
MN329 n329 n328 0 0 NMOD W=10u L=1u
MP330 n330 n329 vdd vdd PMOD W=20u L=1u
MN330 n330 n329 0 0 NMOD W=10u L=1u
MP331 n331 n330 vdd vdd PMOD W=20u L=1u
MN331 n331 n330 0 0 NMOD W=10u L=1u
MP332 n332 n331 vdd vdd PMOD W=20u L=1u
MN332 n332 n331 0 0 NMOD W=10u L=1u
MP333 n333 n332 vdd vdd PMOD W=20u L=1u
MN333 n333 n332 0 0 NMOD W=10u L=1u
MP334 n334 n333 vdd vdd PMOD W=20u L=1u
MN334 n334 n333 0 0 NMOD W=10u L=1u
MP335 n335 n334 vdd vdd PMOD W=20u L=1u
MN335 n335 n334 0 0 NMOD W=10u L=1u
MP336 n336 n335 vdd vdd PMOD W=20u L=1u
MN336 n336 n335 0 0 NMOD W=10u L=1u
MP337 n337 n336 vdd vdd PMOD W=20u L=1u
MN337 n337 n336 0 0 NMOD W=10u L=1u
MP338 n338 n337 vdd vdd PMOD W=20u L=1u
MN338 n338 n337 0 0 NMOD W=10u L=1u
MP339 n339 n338 vdd vdd PMOD W=20u L=1u
MN339 n339 n338 0 0 NMOD W=10u L=1u
MP340 n340 n339 vdd vdd PMOD W=20u L=1u
MN340 n340 n339 0 0 NMOD W=10u L=1u
MP341 n341 n340 vdd vdd PMOD W=20u L=1u
MN341 n341 n340 0 0 NMOD W=10u L=1u
MP342 n342 n341 vdd vdd PMOD W=20u L=1u
MN342 n342 n341 0 0 NMOD W=10u L=1u
MP343 n343 n342 vdd vdd PMOD W=20u L=1u
MN343 n343 n342 0 0 NMOD W=10u L=1u
MP344 n344 n343 vdd vdd PMOD W=20u L=1u
MN344 n344 n343 0 0 NMOD W=10u L=1u
MP345 n345 n344 vdd vdd PMOD W=20u L=1u
MN345 n345 n344 0 0 NMOD W=10u L=1u
MP346 n346 n345 vdd vdd PMOD W=20u L=1u
MN346 n346 n345 0 0 NMOD W=10u L=1u
MP347 n347 n346 vdd vdd PMOD W=20u L=1u
MN347 n347 n346 0 0 NMOD W=10u L=1u
MP348 n348 n347 vdd vdd PMOD W=20u L=1u
MN348 n348 n347 0 0 NMOD W=10u L=1u
MP349 n349 n348 vdd vdd PMOD W=20u L=1u
MN349 n349 n348 0 0 NMOD W=10u L=1u
MP350 n350 n349 vdd vdd PMOD W=20u L=1u
MN350 n350 n349 0 0 NMOD W=10u L=1u
MP351 n351 n350 vdd vdd PMOD W=20u L=1u
MN351 n351 n350 0 0 NMOD W=10u L=1u
MP352 n352 n351 vdd vdd PMOD W=20u L=1u
MN352 n352 n351 0 0 NMOD W=10u L=1u
MP353 n353 n352 vdd vdd PMOD W=20u L=1u
MN353 n353 n352 0 0 NMOD W=10u L=1u
MP354 n354 n353 vdd vdd PMOD W=20u L=1u
MN354 n354 n353 0 0 NMOD W=10u L=1u
MP355 n355 n354 vdd vdd PMOD W=20u L=1u
MN355 n355 n354 0 0 NMOD W=10u L=1u
MP356 n356 n355 vdd vdd PMOD W=20u L=1u
MN356 n356 n355 0 0 NMOD W=10u L=1u
MP357 n357 n356 vdd vdd PMOD W=20u L=1u
MN357 n357 n356 0 0 NMOD W=10u L=1u
MP358 n358 n357 vdd vdd PMOD W=20u L=1u
MN358 n358 n357 0 0 NMOD W=10u L=1u
MP359 n359 n358 vdd vdd PMOD W=20u L=1u
MN359 n359 n358 0 0 NMOD W=10u L=1u
MP360 n360 n359 vdd vdd PMOD W=20u L=1u
MN360 n360 n359 0 0 NMOD W=10u L=1u
MP361 n361 n360 vdd vdd PMOD W=20u L=1u
MN361 n361 n360 0 0 NMOD W=10u L=1u
MP362 n362 n361 vdd vdd PMOD W=20u L=1u
MN362 n362 n361 0 0 NMOD W=10u L=1u
MP363 n363 n362 vdd vdd PMOD W=20u L=1u
MN363 n363 n362 0 0 NMOD W=10u L=1u
MP364 n364 n363 vdd vdd PMOD W=20u L=1u
MN364 n364 n363 0 0 NMOD W=10u L=1u
MP365 n365 n364 vdd vdd PMOD W=20u L=1u
MN365 n365 n364 0 0 NMOD W=10u L=1u
MP366 n366 n365 vdd vdd PMOD W=20u L=1u
MN366 n366 n365 0 0 NMOD W=10u L=1u
MP367 n367 n366 vdd vdd PMOD W=20u L=1u
MN367 n367 n366 0 0 NMOD W=10u L=1u
MP368 n368 n367 vdd vdd PMOD W=20u L=1u
MN368 n368 n367 0 0 NMOD W=10u L=1u
MP369 n369 n368 vdd vdd PMOD W=20u L=1u
MN369 n369 n368 0 0 NMOD W=10u L=1u
MP370 n370 n369 vdd vdd PMOD W=20u L=1u
MN370 n370 n369 0 0 NMOD W=10u L=1u
MP371 n371 n370 vdd vdd PMOD W=20u L=1u
MN371 n371 n370 0 0 NMOD W=10u L=1u
MP372 n372 n371 vdd vdd PMOD W=20u L=1u
MN372 n372 n371 0 0 NMOD W=10u L=1u
MP373 n373 n372 vdd vdd PMOD W=20u L=1u
MN373 n373 n372 0 0 NMOD W=10u L=1u
MP374 n374 n373 vdd vdd PMOD W=20u L=1u
MN374 n374 n373 0 0 NMOD W=10u L=1u
MP375 n375 n374 vdd vdd PMOD W=20u L=1u
MN375 n375 n374 0 0 NMOD W=10u L=1u
MP376 n376 n375 vdd vdd PMOD W=20u L=1u
MN376 n376 n375 0 0 NMOD W=10u L=1u
MP377 n377 n376 vdd vdd PMOD W=20u L=1u
MN377 n377 n376 0 0 NMOD W=10u L=1u
MP378 n378 n377 vdd vdd PMOD W=20u L=1u
MN378 n378 n377 0 0 NMOD W=10u L=1u
MP379 n379 n378 vdd vdd PMOD W=20u L=1u
MN379 n379 n378 0 0 NMOD W=10u L=1u
MP380 n380 n379 vdd vdd PMOD W=20u L=1u
MN380 n380 n379 0 0 NMOD W=10u L=1u
MP381 n381 n380 vdd vdd PMOD W=20u L=1u
MN381 n381 n380 0 0 NMOD W=10u L=1u
MP382 n382 n381 vdd vdd PMOD W=20u L=1u
MN382 n382 n381 0 0 NMOD W=10u L=1u
MP383 n383 n382 vdd vdd PMOD W=20u L=1u
MN383 n383 n382 0 0 NMOD W=10u L=1u
MP384 n384 n383 vdd vdd PMOD W=20u L=1u
MN384 n384 n383 0 0 NMOD W=10u L=1u
MP385 n385 n384 vdd vdd PMOD W=20u L=1u
MN385 n385 n384 0 0 NMOD W=10u L=1u
MP386 n386 n385 vdd vdd PMOD W=20u L=1u
MN386 n386 n385 0 0 NMOD W=10u L=1u
MP387 n387 n386 vdd vdd PMOD W=20u L=1u
MN387 n387 n386 0 0 NMOD W=10u L=1u
MP388 n388 n387 vdd vdd PMOD W=20u L=1u
MN388 n388 n387 0 0 NMOD W=10u L=1u
MP389 n389 n388 vdd vdd PMOD W=20u L=1u
MN389 n389 n388 0 0 NMOD W=10u L=1u
MP390 n390 n389 vdd vdd PMOD W=20u L=1u
MN390 n390 n389 0 0 NMOD W=10u L=1u
MP391 n391 n390 vdd vdd PMOD W=20u L=1u
MN391 n391 n390 0 0 NMOD W=10u L=1u
MP392 n392 n391 vdd vdd PMOD W=20u L=1u
MN392 n392 n391 0 0 NMOD W=10u L=1u
MP393 n393 n392 vdd vdd PMOD W=20u L=1u
MN393 n393 n392 0 0 NMOD W=10u L=1u
MP394 n394 n393 vdd vdd PMOD W=20u L=1u
MN394 n394 n393 0 0 NMOD W=10u L=1u
MP395 n395 n394 vdd vdd PMOD W=20u L=1u
MN395 n395 n394 0 0 NMOD W=10u L=1u
MP396 n396 n395 vdd vdd PMOD W=20u L=1u
MN396 n396 n395 0 0 NMOD W=10u L=1u
MP397 n397 n396 vdd vdd PMOD W=20u L=1u
MN397 n397 n396 0 0 NMOD W=10u L=1u
MP398 n398 n397 vdd vdd PMOD W=20u L=1u
MN398 n398 n397 0 0 NMOD W=10u L=1u
MP399 n399 n398 vdd vdd PMOD W=20u L=1u
MN399 n399 n398 0 0 NMOD W=10u L=1u
MP400 n400 n399 vdd vdd PMOD W=20u L=1u
MN400 n400 n399 0 0 NMOD W=10u L=1u
.op
.end
