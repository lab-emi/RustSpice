V1 in 0 DC 8
* bench.id: cap_lang_syn_no_title_line
* bench.group: capability
* bench.title: the first line is a card, so it is consumed as the title and V1 is lost (circuit floats at 0 V)
* bench.probes: v(out)
* bench.tags: linear, op, syntax, title
R1 in out 3k
R2 out 0 1k
V2 in 0 DC 4
.op
.end
