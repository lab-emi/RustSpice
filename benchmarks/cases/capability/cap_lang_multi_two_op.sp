Two operating point cards
* bench.id: cap_lang_multi_two_op
* bench.group: capability
* bench.title: two .op cards in one deck each produce a plot
* bench.probes: v(out)
* bench.tags: linear, multi_analysis, op
V1 in 0 3
R1 in out 1k
R2 out 0 2k
.op
.op
.end
