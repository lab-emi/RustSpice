Tabs and trailing whitespace
* bench.id: cap_lang_syn_tabs_whitespace
* bench.group: capability
* bench.title: tab separators, leading blanks and trailing blanks on every card
* bench.probes: v(out)
* bench.tags: linear, op, syntax, whitespace
V1	in	0	DC	8
   R1  	 in   out	3k
		R2 out	0	1k
.op
.end
