No newline after the last card
* bench.id: cap_lang_syn_no_final_newline
* bench.group: capability
* bench.title: the file ends right after ".end" with no line terminator
* bench.probes: v(out)
* bench.tags: linear, op, syntax, termination
V1 in 0 DC 8
R1 in out 3k
R2 out 0 1k
.op
.end
