Blank lines everywhere
* bench.id: cap_lang_syn_blank_lines
* bench.group: capability
* bench.title: empty and blank-only lines between cards and before .op / .end
* bench.probes: v(out)
* bench.tags: linear, op, syntax, whitespace

V1 in 0 DC 8

R1 in out 3k

R2 out 0 1k

.op

.end
