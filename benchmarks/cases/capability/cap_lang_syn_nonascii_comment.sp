Non-ASCII text in title and comments é€Ω
* bench.id: cap_lang_syn_nonascii_comment
* bench.group: capability
* bench.title: UTF-8 text (e-acute, euro, omega) in the title and in a comment
* bench.probes: v(out)
* bench.tags: linear, op, syntax, encoding
* résistance € 3k Ω
V1 in 0 DC 8
R1 in out 3k ; Ω
R2 out 0 1k
.op
.end
