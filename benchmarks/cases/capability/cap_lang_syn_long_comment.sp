Very long comment line
* bench.id: cap_lang_syn_long_comment
* bench.group: capability
* bench.title: a 20000-character comment line and a 2000-character trailing comment next to a divider
* bench.probes: v(out)
* bench.tags: linear, op, syntax, long_line
* long comment text long comment text long comment text long comment text long comment text long comment text long comment text long comment text long comment text long comment text long comment text long comment text long comment text long comment text long comment text long comment text long comment text long comment text long comment text long comment text long comment text long comment text long comment text long comment text long comment text long comment text long comment text long comment text long comment text long comment text long comment text long comment text long comment text long comment text long comment text long comment text long comment text long comment text long comment text long comment text long comment text long comment text long comment text long comment text long comment text long comment text long comment text long comment text long comment text long comment text long comment text long comment text long comment text long comment text long comment text long comment text long comment text long comment text long comment text long comment text long comment text long comment text long comment text long comment text long comment text long comment text long comment text long comment text long comment text long comment text long comment text long comment text long comment text long comment text long comment text long comment text long comment text long comment text long comment text long comment text long comment text long comment text long comment text long comment text long comment text long comment text long comment text long comment text long comment text long comment text long comment text long comment text long comment text long comment text long comment text long comment text long comment text long comment text long comment text long comment text long comment text long comment text long comment text long comment text long comment text long comment text long comment text long comment text long comment text long comment text long comment text long comment text long comment text long comment text long comment text long comment text long comment text long comment text long comment text long comment text long comment text long comment text long comment text long comment text long comment text long comment text long comment text long comment text long comment text long comment text long comment text long comment text long comment text long comment text long comment text long comment text long comment text long comment text long comment text long comment text long comment text long comment text long comment text long comment text long comment text long comment text long comment text long comment text long comment text long comment text long comment text long comment text long comment text long comment text long comment text long comment text long comment text long comment text long comment text long comment text long comment text long comment text long comment text long comment text long comment text long comment text long comment text long comment text long comment text long comment text long comment text long comment text long comment text long comment text long comment text long comment text long comment text long comment text long comment text long comment text long comment text long comment text long comment text long comment text long comment text long comment text long comment text long comment text long comment text long comment text long comment text long comment text long comment text long comment text long comment text long comment text long comment text long comment text long comment text long comment text long comment text long comment text long comment text long comment text long comment text long comment text long comment text long comment text long comment text long comment text long comment text long comment text long comment text long comment text long comment text long comment text long comment text long comment text long comment text long comment text long comment text long comment text long comment text long comment text long comment text long comment text long comment text long comment text long comment text long comment text long comment text long comment text long comment text long comment text long comment text long comment text long comment text long comment text long comment text long comment text long comment text long comment text long comment text long comment text long comment text long comment text long comment text long comment text long comment text long comment text long comment text long comment text long comment text long comment text long comment text long comment text long comment text long comment text long comment text long comment text long comment text long comment text long comment text long comment text long comment text long comment text long comment text long comment text long comment text long comment text long comment text long comment text long comment text long comment text long comment text long comment text long comment text long comment text long comment text long comment text long comment text long comment text long comment text long comment text long comment text long comment text long comment text long comment text long comment text long comment text long comment text long comment text long comment text long comment text long comment text long comment text long comment text long comment text long comment text long comment text long comment text long comment text long comment text long comment text long comment text long comment text long comment text long comment text long comment text long comment text long comment text long comment text long comment text long comment text long comment text long comment text long comment text long comment text long comment text long comment text long comment text long comment text long comment text long comment text long comment text long comment text long comment text long comment text long comment text long comment text long comment text long comment text long comment text long comment text long comment text long comment text long comment text long comment text long comment text long comment text long comment text long comment text long comment text long comment text long comment text long comment text long comment text long comment text long comment text long comment text long comment text long comment text long comment text long comment text long comment text long comment text long comment text long comment text long comment text long comment text long comment text long comment text long comment text long comment text long comment text long comment text long comment text long comment text long comment text long comment text long comment text long comment text long comment text long comment text long comment text long comment text long comment text long comment text long comment text long comment text long comment text long comment text long comment text long comment text long comment text long comment text long comment text long comment text long comment text long comment text long comment text long comment text long comment text long comment text long comment text long comment text long comment text long comment text long comment text long comment text long comment text long comment text long comment text long comment text long comment text long comment text long comment text long comment text long comment text long comment text long comment text long comment text long comment text long comment text long comment text long comment text long comment text long comment text long comment text long comment text long comment text long comment text long comment text long comment text long comment text long comment text long comment text long comment text long comment text long comment text long comment text long comment text long comment text long comment text long comment text long comment text long comment text long comment text long comment text long comment text long comment text long comment text long comment text long comment text long comment text long comment text long comment text long comment text long comment text long comment text long comment text long comment text long comment text long comment text long comment text long comment text long comment text long comment text long comment text long comment text long comment text long comment text long comment text long comment text long comment text long comment text long comment text long comment text long comment text long comment text long comment text long comment text long comment text long comment text long comment text long comment text long comment text long comment text long comment text long comment text long comment text long comment text long comment text long comment text long comment text long comment text long comment text long comment text long comment text long comment text long comment text long comment text long comment text long comment text long comment text long comment text long comment text long comment text long comment text long comment text long comment text long comment text long comment text long comment text long comment text long comment text long comment text long comment text long comment text long comment text long comment text long comment text long comment text long comment text long comment text long comment text long comment text long comment text long comment text long comment text long comment text long comment text long comment text long comment text long comment text long comment text long comment text long comment text long comment text long comment text long comment text long comment text long comment text long comment text long comment text long comment text long comment text long comment text long comment text long comment text long comment text long comment text long comment text long comment text long comment text long comment text long comment text long comment text long comment text long comment text long comment text long comment text long comment text long comment text long comment text long comment text long comment text long comment text long comment text long comment text long comment text long comment text long comment text long comment text long comment text long comment text long comment text long comment text long comment text long comment text long comment text long comment text long comment text long comment text long comment text long comment text long comment text long comment text long comment text long comment text long comment text long comment text long comment text long comment text long comment text long comment text long comment text long comment text long comment text long comment text long comment text long comment text long comment text long comment text long comment text long comment text long comment text long comment text long comment text long comment text long comment text long comment text long comment text long comment text long comment text long comment text long comment text long comment text long comment text long comment text long comment text long comment text long comment text long comment text long comment text long comment text long comment text long comment text long comment text long comment text long comment text long comment text long comment text long comment text long comment text long comment text long comment text long comment text long comment text long comment text long comment text long comment text long comment text long comment text long comment text long comment text long comment text long comment text long comment text long comment text long comment text long comment text long comment text long comment text long comment text long comment text long comment text long comment text long comment text long comment text long comment text long comment text long comment text long comment text long comment text long comment text long comment text long comment text long comment text long comment text long comment text long comment text long comment text long comment text long comment text long comment text long comment text long comment text long comment text long comment text long comment text long comment text long comment text long comment text long comment text long comment text long comment text long comment text long comment text long comment text long comment text long comment text long comment text long comment text long comment text long comment text long comment text long comment text long comment text long comment text long comment text long comment text long comment text long comment text long comment text long comment text long comment text long comment text long comment text long comment text long comment text long comment text long comment text long comment text long comment text long comment text long comment text long comment text long comment text long comment text long comment text long comment text long comment text long comment text long comment text long comment text long comment text long comment text long comment text long comment text long comment text long comment text long comment text long comment text long comment text long comment text long comment text long comment text long comment text long comment text long comment text long comment text long comment text long comment text long comment text long comment text long comment text long comment text long comment text long comment text long comment text long comment text long comment text long comment text long comment text long comment text long comment text long comment text long comment text long comment text long comment text long comment text long comment text long comment text long comment text long comment text long comment text long comment text long comment text long comment text long comment text long comment text long comment text long comment text long comment text long comment text long comment text long comment text long comment text long comment text long comment text long comment text long comment text long comment text long comment text long comment text long comment text long comment text long comment text long comment text long comment text long comment text long comment text long comment text long comment text long comment text long comment text long comment text long comment text long comment text long comment text long comment text long comment text long comment text long comment text long comment text long comment text long comment text long comment text long comment text long comment text long comment text long comment text long comment text long comment text long comment text long comment text long comment text long comment text long comment text long comment text long comment text long comment text long comment text long comment text long comment text long comment text long comment text long comment text long comment text long comment text long comment text long comment text long comment text long comment text long comment text long comment text long comment text long comment text long comment text long comment text long comment text long comment text long comment text long comment text long comment text long comment text long comment text long comment text long comment text long comment text long comment text long comment text long comment text long comment text long comment text long comment text long comment text long comment text long comment text long comment text long comment text long comment text long comment text long comment text long comment text long comment text long comment text long comment text long comment text long comment text long comment text long comment text long comment text long comment text long comment text long comment text long comment text long comment text long comment text long comment text long comment text long comment text long comment text long comment text long comment text long comment text long comment text long comment text long comment text long comment text long comment text long comment text long comment text long comment text long comment text long comment text long comment text long comment text long comment text long comment text long comment text long comment text long comment text long comment text long comment text long comment text long comment text long comment text long comment text long comment text long comment text long comment text long comment text long comment text long comment text long comment text long comment text long comment text long comment text long comment text long comment text long comment text long comment text long comment text long comment text long comment text long comment text long comment text long comment text long comment text long comment text long comment text long comment text long comment text long comment text long comment text long comment text long comment text long comment text long comment text long comment text long comment text long comment text long comment text long comment text long comment text long comment text long comment text long comment text long comment text long comment text long comment text long comment text long comment text long comment text long comment text long comment text long comment text long comment text long comment text long comment text long comment text long comment text long comment text long comment text long comment text long comment text long comment text long comment text long comment text long comment text long comment text long comment text long comment text long comment text long comment text long comment text long comment text long comment text long comment text long comment text long comment text long comment text long comment text long comment text long comment text long comment text long comment text long comment text long comment text long comment text long comment text long comment text long comment text long comment text long comment text long comment text long comment text long comment text long comment text long comment text long comment text long comment text long comment text long comment text long comment text long comment text long comment text long comment text long comment text long comment text long comment text long comment text long comment text long comment text long comment text long comment text long comment text long comment text long comment text long comment text long comment text long comment text long comment text long comment text long comment text long comment text long comment text long comment text long comment text long comment text long comment text long comment text long comment text long comment text long comment text long comment text long comment text long comment text long comment text long comment text long comment text long comment text long comment text long comment text long comment text long comment text long comment text long comment text long comment text long comment text long comment text long comment text long comment text long comment text long comment text long comment text long comment text long comment text long comment text long comment text long comment text long comment text long comment text long comment text long comment text long comment text long comment text long comment text long comment text long comment text long comment text long comment text long comment text long comment text long comment text long comment text long comment text long comment text long comment text long comment text long comment text long comment text long comment text long comment text long comment text long comment text long comment text long comment text long comment text long comment text long comment text long comment text long comment text long comment text long comment text long comment text long comment text long comment text long comment text long comment text long comment text long comment text long comment text long comment text long comment text long comment text long comment text long comment text long comment text long comment text long comment text long comment text long comment text long comment text long comment text long comment text long comment text long comment text long comment text long comment text long comment text long comment text long comment text long comment text long comment text long comment text long comment text long comment text long comment text long comment text long comment text long comment text long comment text long comment text long comment text long comment text long comment text long comment text long comment text long comment text long comment text long comment text long comment text long comment text long comment text long comment text long comment text long comment text long comment text long comment text long comment text long comment text long comment text long comment text long comment text long comment text long comment text long comment text long comment text long comment text long comment text long comment text long comment text long comment text long comment text long comment text long comment text long comment text long comment text long comment text long comment text long comment text long comment text long comment text long comment text long comment text long comment text long comment text long comment text long comment text long comment text long comment text long comment text long comment text long comment text long comment text long comment text long comment text long comment text long comment text long comment text long comment text long comment text long comment text long comment text long comment text long comment text long comment text long comment text long comment text long comment text long comment text long comment text long comment text long comment text long comment text long comment text long comment text
V1 in 0 DC 8
R1 in out 3k ; xxxxxxxxxxxxxxxxxxxxxxxxxxxxxxxxxxxxxxxxxxxxxxxxxxxxxxxxxxxxxxxxxxxxxxxxxxxxxxxxxxxxxxxxxxxxxxxxxxxxxxxxxxxxxxxxxxxxxxxxxxxxxxxxxxxxxxxxxxxxxxxxxxxxxxxxxxxxxxxxxxxxxxxxxxxxxxxxxxxxxxxxxxxxxxxxxxxxxxxxxxxxxxxxxxxxxxxxxxxxxxxxxxxxxxxxxxxxxxxxxxxxxxxxxxxxxxxxxxxxxxxxxxxxxxxxxxxxxxxxxxxxxxxxxxxxxxxxxxxxxxxxxxxxxxxxxxxxxxxxxxxxxxxxxxxxxxxxxxxxxxxxxxxxxxxxxxxxxxxxxxxxxxxxxxxxxxxxxxxxxxxxxxxxxxxxxxxxxxxxxxxxxxxxxxxxxxxxxxxxxxxxxxxxxxxxxxxxxxxxxxxxxxxxxxxxxxxxxxxxxxxxxxxxxxxxxxxxxxxxxxxxxxxxxxxxxxxxxxxxxxxxxxxxxxxxxxxxxxxxxxxxxxxxxxxxxxxxxxxxxxxxxxxxxxxxxxxxxxxxxxxxxxxxxxxxxxxxxxxxxxxxxxxxxxxxxxxxxxxxxxxxxxxxxxxxxxxxxxxxxxxxxxxxxxxxxxxxxxxxxxxxxxxxxxxxxxxxxxxxxxxxxxxxxxxxxxxxxxxxxxxxxxxxxxxxxxxxxxxxxxxxxxxxxxxxxxxxxxxxxxxxxxxxxxxxxxxxxxxxxxxxxxxxxxxxxxxxxxxxxxxxxxxxxxxxxxxxxxxxxxxxxxxxxxxxxxxxxxxxxxxxxxxxxxxxxxxxxxxxxxxxxxxxxxxxxxxxxxxxxxxxxxxxxxxxxxxxxxxxxxxxxxxxxxxxxxxxxxxxxxxxxxxxxxxxxxxxxxxxxxxxxxxxxxxxxxxxxxxxxxxxxxxxxxxxxxxxxxxxxxxxxxxxxxxxxxxxxxxxxxxxxxxxxxxxxxxxxxxxxxxxxxxxxxxxxxxxxxxxxxxxxxxxxxxxxxxxxxxxxxxxxxxxxxxxxxxxxxxxxxxxxxxxxxxxxxxxxxxxxxxxxxxxxxxxxxxxxxxxxxxxxxxxxxxxxxxxxxxxxxxxxxxxxxxxxxxxxxxxxxxxxxxxxxxxxxxxxxxxxxxxxxxxxxxxxxxxxxxxxxxxxxxxxxxxxxxxxxxxxxxxxxxxxxxxxxxxxxxxxxxxxxxxxxxxxxxxxxxxxxxxxxxxxxxxxxxxxxxxxxxxxxxxxxxxxxxxxxxxxxxxxxxxxxxxxxxxxxxxxxxxxxxxxxxxxxxxxxxxxxxxxxxxxxxxxxxxxxxxxxxxxxxxxxxxxxxxxxxxxxxxxxxxxxxxxxxxxxxxxxxxxxxxxxxxxxxxxxxxxxxxxxxxxxxxxxxxxxxxxxxxxxxxxxxxxxxxxxxxxxxxxxxxxxxxxxxxxxxxxxxxxxxxxxxxxxxxxxxxxxxxxxxxxxxxxxxxxxxxxxxxxxxxxxxxxxxxxxxxxxxxxxxxxxxxxxxxxxxxxxxxxxxxxxxxxxxxxxxxxxxxxxxxxxxxxxxxxxxxxxxxxxxxxxxxxxxxxxxxxxxxxxxxxxxxxxxxxxxxxxxxxxxxxxxxxxxxxxxxxxxxxxxxxxxxxxxxxxxxxxxxxxxxxxxxxxxxxxxxxxxxxxxxxxxxxxxxxxxxxxxxxxxxxxxxxxxxxxxxxxxxxxxxxxxxxxxxxxxxxxxxxxxxxxxxxxxxxxxxxxxxxxxxxxxxxxxxxxxxxxxxxxxxxxxxxxxxxxxxxxxxxxxxxxxxxxxxxxxxxxxxxxxxxxxxxxxxxxxxxxxxxxxxxxxxxxxxxxxxxxxxxxxxxxxxxxxxxxxxxxxxxxxxxxxxxxxxxxxxxxxxxxxxxxxxxxxxxxxxxxxxxxxxxxxxxxxxxxxxxxxxxxxxxxxxxxxxxxxxxxxxxxxxxxxxxxxxxxxxxxxxxxxxxxxxxxxxxxxxxxxxxxxxxxxxxxxxxxxx
R2 out 0 1k
.op
.end
