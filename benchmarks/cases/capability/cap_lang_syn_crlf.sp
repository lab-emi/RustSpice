CRLF line endings
* bench.id: cap_lang_syn_crlf
* bench.group: capability
* bench.title: every line ends in CR LF (a deck saved on Windows)
* bench.probes: v(out)
* bench.tags: linear, op, syntax, line_endings
V1 in 0 DC 8
R1 in out 3k
R2 out 0
+ 1k
.op
.end
