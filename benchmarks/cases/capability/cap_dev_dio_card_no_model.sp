Diode card without a model name
* bench.id: cap_dev_dio_card_no_model
* bench.group: capability
* bench.title: Diode card without a model name
* bench.probes: i(v1)
* bench.expect: loud_error
* bench.tags: diode, card_syntax, ngspice_error_ok
V1 a 0 0.7
D1 a 0
.op
.end
