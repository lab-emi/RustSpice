Full-line star comments
* bench.id: cap_lang_syn_comment_star_lines
* bench.group: capability
* bench.title: star comments, empty star lines and a comment that looks like a card (* R9 out 0 1)
* bench.probes: v(out)
* bench.tags: linear, op, syntax, comment
*
* a comment block
* R9 out 0 1
V1 in 0 DC 8
*R3 out 0 1
R1 in out 3k
R2 out 0 1k
*
.op
.end
