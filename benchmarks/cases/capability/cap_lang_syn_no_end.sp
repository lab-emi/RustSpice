Deck without .end
* bench.id: cap_lang_syn_no_end
* bench.group: capability
* bench.title: the last card is .op; there is no .end line at all
* bench.probes: v(out)
* bench.tags: linear, op, syntax, termination
V1 in 0 DC 8
R1 in out 3k
R2 out 0 1k
.op
