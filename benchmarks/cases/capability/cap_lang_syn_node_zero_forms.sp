Node 0 written in several ways
* bench.id: cap_lang_syn_node_zero_forms
* bench.group: capability
* bench.title: node 00 is an ordinary node; only the literal 0 (and gnd) is ground
* bench.probes: v(out), v(00)
* bench.tags: linear, op, syntax, node_names, ground
V1 in 0 DC 12
R1 in out 1k
R2 out 00 1k
R3 00 0 2k
.op
.end
