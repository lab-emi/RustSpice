Continuation line on an element card
* bench.id: cap_lang_syn_cont_element
* bench.group: capability
* bench.title: '+' continuation splits an element card across lines (R1 in out / + 3k)
* bench.probes: v(out)
* bench.tags: linear, op, syntax, continuation
V1 in 0 DC 8
R1 in out
+ 3k
R2 out 0
+ 1k
.op
.end
