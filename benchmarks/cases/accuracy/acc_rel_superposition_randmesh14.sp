Superposition on a random 14x14 resistor mesh: V1 + V2 + I3 versus the three single-source solves
* bench.id: acc_rel_superposition_randmesh14
* bench.group: accuracy
* bench.title: Superposition v(V1+V2+I3) = v(V1) + v(V2) + v(I3) on a random 14x14 mesh (R log-uniform 1e-2..1e2): 4 copies, 4 relation nodes
* bench.probes: v(r_3_3), v(r_7_11), v(r_11_7), v(r_12_2), v(fn3_3), v(fn7_11), v(fn11_7), v(fn12_2)
* bench.tol.rel: 0
* bench.tol.abs: 1e-10
* bench.expect: match
* bench.oracle: dc_linear
* bench.size: 806
* bench.tags: linear, op, mesh, relation, twin_block, ill_conditioned, reference_free, superposition
* bench.est_rss_mib: 16
* bench.note: Copy f carries V1 = 1 V (corner pad), V2 = -0.7 V (opposite corner pad) and I3 = 0.5 A (interior node); copies a, b, c carry one source each (the others are 0 V / 0 A); r_x = 1 + (v_f - v_a - v_b - v_c)(x) with unit gain through non-loading VCCS cards, exact value 1 (python dense oracle |r-1| = 0, ngspice-tight <= 5.1e-15). Gate tol.abs 1e-10 V = 1e-10 of the 1 V full scale. RustSpice (UnrolledSymbolic) |r-1| <= 1.9e-12, margin 53x; the residual is circuit specific on this tier (the mesh with seed 11 gives ~2e-15). Probes also include v_f at the 4 nodes.
rfrh0_0 fn0_0 fn0_1 0.07949
rfrv0_0 fn0_0 fn1_0 0.043191
rfrh0_1 fn0_1 fn0_2 0.028901
rfrv0_1 fn0_1 fn1_1 0.77446
rfrh0_2 fn0_2 fn0_3 2.1612
rfrv0_2 fn0_2 fn1_2 0.05834
rfrh0_3 fn0_3 fn0_4 0.16298
rfrv0_3 fn0_3 fn1_3 21.178
rfrh0_4 fn0_4 fn0_5 5.4182
rfrv0_4 fn0_4 fn1_4 2.4593
rfrh0_5 fn0_5 fn0_6 0.46846
rfrv0_5 fn0_5 fn1_5 4.968
rfrh0_6 fn0_6 fn0_7 0.02753
rfrv0_6 fn0_6 fn1_6 0.13939
rfrh0_7 fn0_7 fn0_8 6.0318
rfrv0_7 fn0_7 fn1_7 60.963
rfrh0_8 fn0_8 fn0_9 0.21165
rfrv0_8 fn0_8 fn1_8 1.6668
rfrh0_9 fn0_9 fn0_10 0.010995
rfrv0_9 fn0_9 fn1_9 0.023165
rfrh0_10 fn0_10 fn0_11 16.849
rfrv0_10 fn0_10 fn1_10 10.344
rfrh0_11 fn0_11 fn0_12 2.5996
rfrv0_11 fn0_11 fn1_11 3.9229
rfrh0_12 fn0_12 fn0_13 0.011808
rfrv0_12 fn0_12 fn1_12 0.19891
rfrv0_13 fn0_13 fn1_13 34.492
rfrh1_0 fn1_0 fn1_1 13.64
rfrv1_0 fn1_0 fn2_0 0.024922
rfrh1_1 fn1_1 fn1_2 0.13267
rfrv1_1 fn1_1 fn2_1 0.40219
rfrh1_2 fn1_2 fn1_3 1.7994
rfrv1_2 fn1_2 fn2_2 0.26296
rfrh1_3 fn1_3 fn1_4 0.38977
rfrv1_3 fn1_3 fn2_3 1.202
rfrh1_4 fn1_4 fn1_5 0.30597
rfrv1_4 fn1_4 fn2_4 0.23269
rfrh1_5 fn1_5 fn1_6 0.031318
rfrv1_5 fn1_5 fn2_5 1.0647
rfrh1_6 fn1_6 fn1_7 6.0872
rfrv1_6 fn1_6 fn2_6 0.25332
rfrh1_7 fn1_7 fn1_8 3.5917
rfrv1_7 fn1_7 fn2_7 0.85048
rfrh1_8 fn1_8 fn1_9 0.6922
rfrv1_8 fn1_8 fn2_8 45.621
rfrh1_9 fn1_9 fn1_10 0.71431
rfrv1_9 fn1_9 fn2_9 0.13417
rfrh1_10 fn1_10 fn1_11 0.013207
rfrv1_10 fn1_10 fn2_10 0.54203
rfrh1_11 fn1_11 fn1_12 5.5036
rfrv1_11 fn1_11 fn2_11 5.0865
rfrh1_12 fn1_12 fn1_13 10.943
rfrv1_12 fn1_12 fn2_12 1.2935
rfrv1_13 fn1_13 fn2_13 34.522
rfrh2_0 fn2_0 fn2_1 0.13683
rfrv2_0 fn2_0 fn3_0 0.14296
rfrh2_1 fn2_1 fn2_2 0.020727
rfrv2_1 fn2_1 fn3_1 0.29661
rfrh2_2 fn2_2 fn2_3 69.16
rfrv2_2 fn2_2 fn3_2 0.013871
rfrh2_3 fn2_3 fn2_4 0.38808
rfrv2_3 fn2_3 fn3_3 0.72185
rfrh2_4 fn2_4 fn2_5 82.573
rfrv2_4 fn2_4 fn3_4 0.016368
rfrh2_5 fn2_5 fn2_6 34.725
rfrv2_5 fn2_5 fn3_5 15.726
rfrh2_6 fn2_6 fn2_7 40.729
rfrv2_6 fn2_6 fn3_6 0.1815
rfrh2_7 fn2_7 fn2_8 0.339
rfrv2_7 fn2_7 fn3_7 80.753
rfrh2_8 fn2_8 fn2_9 0.17824
rfrv2_8 fn2_8 fn3_8 0.015231
rfrh2_9 fn2_9 fn2_10 0.26242
rfrv2_9 fn2_9 fn3_9 2.1893
rfrh2_10 fn2_10 fn2_11 0.039898
rfrv2_10 fn2_10 fn3_10 65.903
rfrh2_11 fn2_11 fn2_12 6.0463
rfrv2_11 fn2_11 fn3_11 1.712
rfrh2_12 fn2_12 fn2_13 7.8001
rfrv2_12 fn2_12 fn3_12 0.41694
rfrv2_13 fn2_13 fn3_13 1.8557
rfrh3_0 fn3_0 fn3_1 0.12409
rfrv3_0 fn3_0 fn4_0 68.908
rfrh3_1 fn3_1 fn3_2 0.40098
rfrv3_1 fn3_1 fn4_1 0.015704
rfrh3_2 fn3_2 fn3_3 2.9761
rfrv3_2 fn3_2 fn4_2 4.1782
rfrh3_3 fn3_3 fn3_4 32.687
rfrv3_3 fn3_3 fn4_3 10.885
rfrh3_4 fn3_4 fn3_5 92.17
rfrv3_4 fn3_4 fn4_4 0.5774
rfrh3_5 fn3_5 fn3_6 14.271
rfrv3_5 fn3_5 fn4_5 0.025447
rfrh3_6 fn3_6 fn3_7 0.011217
rfrv3_6 fn3_6 fn4_6 57.129
rfrh3_7 fn3_7 fn3_8 5.6204
rfrv3_7 fn3_7 fn4_7 12.873
rfrh3_8 fn3_8 fn3_9 66.15
rfrv3_8 fn3_8 fn4_8 4.167
rfrh3_9 fn3_9 fn3_10 29.546
rfrv3_9 fn3_9 fn4_9 11.991
rfrh3_10 fn3_10 fn3_11 0.84034
rfrv3_10 fn3_10 fn4_10 1.5378
rfrh3_11 fn3_11 fn3_12 0.77671
rfrv3_11 fn3_11 fn4_11 0.97199
rfrh3_12 fn3_12 fn3_13 0.031234
rfrv3_12 fn3_12 fn4_12 48.476
rfrv3_13 fn3_13 fn4_13 1.6643
rfrh4_0 fn4_0 fn4_1 7.9116
rfrv4_0 fn4_0 fn5_0 0.40806
rfrh4_1 fn4_1 fn4_2 0.04472
rfrv4_1 fn4_1 fn5_1 4.545
rfrh4_2 fn4_2 fn4_3 0.034361
rfrv4_2 fn4_2 fn5_2 36.836
rfrh4_3 fn4_3 fn4_4 26.16
rfrv4_3 fn4_3 fn5_3 0.20188
rfrh4_4 fn4_4 fn4_5 0.62895
rfrv4_4 fn4_4 fn5_4 2.3787
rfrh4_5 fn4_5 fn4_6 0.012442
rfrv4_5 fn4_5 fn5_5 0.019225
rfrh4_6 fn4_6 fn4_7 18.08
rfrv4_6 fn4_6 fn5_6 6.437
rfrh4_7 fn4_7 fn4_8 0.018971
rfrv4_7 fn4_7 fn5_7 0.24233
rfrh4_8 fn4_8 fn4_9 7.7019
rfrv4_8 fn4_8 fn5_8 0.17618
rfrh4_9 fn4_9 fn4_10 0.015317
rfrv4_9 fn4_9 fn5_9 1.8787
rfrh4_10 fn4_10 fn4_11 19.61
rfrv4_10 fn4_10 fn5_10 1.0689
rfrh4_11 fn4_11 fn4_12 0.2415
rfrv4_11 fn4_11 fn5_11 0.46929
rfrh4_12 fn4_12 fn4_13 0.89046
rfrv4_12 fn4_12 fn5_12 13.198
rfrv4_13 fn4_13 fn5_13 4.9925
rfrh5_0 fn5_0 fn5_1 23
rfrv5_0 fn5_0 fn6_0 0.25447
rfrh5_1 fn5_1 fn5_2 0.019077
rfrv5_1 fn5_1 fn6_1 0.040085
rfrh5_2 fn5_2 fn5_3 9.1707
rfrv5_2 fn5_2 fn6_2 36.957
rfrh5_3 fn5_3 fn5_4 36.669
rfrv5_3 fn5_3 fn6_3 3.7385
rfrh5_4 fn5_4 fn5_5 0.13621
rfrv5_4 fn5_4 fn6_4 0.37056
rfrh5_5 fn5_5 fn5_6 2.2891
rfrv5_5 fn5_5 fn6_5 35.826
rfrh5_6 fn5_6 fn5_7 63.361
rfrv5_6 fn5_6 fn6_6 38.612
rfrh5_7 fn5_7 fn5_8 29.633
rfrv5_7 fn5_7 fn6_7 0.67233
rfrh5_8 fn5_8 fn5_9 4.1311
rfrv5_8 fn5_8 fn6_8 1.4558
rfrh5_9 fn5_9 fn5_10 9.9609
rfrv5_9 fn5_9 fn6_9 1.6093
rfrh5_10 fn5_10 fn5_11 0.67203
rfrv5_10 fn5_10 fn6_10 6.2123
rfrh5_11 fn5_11 fn5_12 40.961
rfrv5_11 fn5_11 fn6_11 9.9189
rfrh5_12 fn5_12 fn5_13 0.022801
rfrv5_12 fn5_12 fn6_12 7.8165
rfrv5_13 fn5_13 fn6_13 0.20934
rfrh6_0 fn6_0 fn6_1 0.36185
rfrv6_0 fn6_0 fn7_0 0.030169
rfrh6_1 fn6_1 fn6_2 0.39251
rfrv6_1 fn6_1 fn7_1 0.02581
rfrh6_2 fn6_2 fn6_3 3.5432
rfrv6_2 fn6_2 fn7_2 5.7127
rfrh6_3 fn6_3 fn6_4 24.462
rfrv6_3 fn6_3 fn7_3 0.47624
rfrh6_4 fn6_4 fn6_5 1.2544
rfrv6_4 fn6_4 fn7_4 0.015166
rfrh6_5 fn6_5 fn6_6 15.202
rfrv6_5 fn6_5 fn7_5 1.0369
rfrh6_6 fn6_6 fn6_7 68.81
rfrv6_6 fn6_6 fn7_6 3.4048
rfrh6_7 fn6_7 fn6_8 15.495
rfrv6_7 fn6_7 fn7_7 0.6625
rfrh6_8 fn6_8 fn6_9 0.35928
rfrv6_8 fn6_8 fn7_8 0.20089
rfrh6_9 fn6_9 fn6_10 38.517
rfrv6_9 fn6_9 fn7_9 41.402
rfrh6_10 fn6_10 fn6_11 0.010792
rfrv6_10 fn6_10 fn7_10 3.86
rfrh6_11 fn6_11 fn6_12 0.63189
rfrv6_11 fn6_11 fn7_11 35.075
rfrh6_12 fn6_12 fn6_13 25.152
rfrv6_12 fn6_12 fn7_12 0.41562
rfrv6_13 fn6_13 fn7_13 31.334
rfrh7_0 fn7_0 fn7_1 0.075579
rfrv7_0 fn7_0 fn8_0 76
rfrh7_1 fn7_1 fn7_2 0.32575
rfrv7_1 fn7_1 fn8_1 2.6932
rfrh7_2 fn7_2 fn7_3 54.979
rfrv7_2 fn7_2 fn8_2 0.36634
rfrh7_3 fn7_3 fn7_4 55.475
rfrv7_3 fn7_3 fn8_3 5.7295
rfrh7_4 fn7_4 fn7_5 0.13068
rfrv7_4 fn7_4 fn8_4 8.8078
rfrh7_5 fn7_5 fn7_6 0.65371
rfrv7_5 fn7_5 fn8_5 0.015192
rfrh7_6 fn7_6 fn7_7 0.015676
rfrv7_6 fn7_6 fn8_6 0.013824
rfrh7_7 fn7_7 fn7_8 5.5302
rfrv7_7 fn7_7 fn8_7 0.073462
rfrh7_8 fn7_8 fn7_9 0.1036
rfrv7_8 fn7_8 fn8_8 0.45409
rfrh7_9 fn7_9 fn7_10 0.074468
rfrv7_9 fn7_9 fn8_9 0.18253
rfrh7_10 fn7_10 fn7_11 0.247
rfrv7_10 fn7_10 fn8_10 0.12481
rfrh7_11 fn7_11 fn7_12 10.966
rfrv7_11 fn7_11 fn8_11 0.072396
rfrh7_12 fn7_12 fn7_13 72.642
rfrv7_12 fn7_12 fn8_12 0.10097
rfrv7_13 fn7_13 fn8_13 5.9482
rfrh8_0 fn8_0 fn8_1 0.12867
rfrv8_0 fn8_0 fn9_0 0.27021
rfrh8_1 fn8_1 fn8_2 0.019452
rfrv8_1 fn8_1 fn9_1 0.078267
rfrh8_2 fn8_2 fn8_3 5.2072
rfrv8_2 fn8_2 fn9_2 0.010993
rfrh8_3 fn8_3 fn8_4 0.3659
rfrv8_3 fn8_3 fn9_3 1.8531
rfrh8_4 fn8_4 fn8_5 0.28307
rfrv8_4 fn8_4 fn9_4 0.012207
rfrh8_5 fn8_5 fn8_6 1.601
rfrv8_5 fn8_5 fn9_5 1.6014
rfrh8_6 fn8_6 fn8_7 0.38778
rfrv8_6 fn8_6 fn9_6 0.14101
rfrh8_7 fn8_7 fn8_8 0.025189
rfrv8_7 fn8_7 fn9_7 0.31118
rfrh8_8 fn8_8 fn8_9 0.11865
rfrv8_8 fn8_8 fn9_8 91.926
rfrh8_9 fn8_9 fn8_10 37.363
rfrv8_9 fn8_9 fn9_9 0.017907
rfrh8_10 fn8_10 fn8_11 50.476
rfrv8_10 fn8_10 fn9_10 0.048368
rfrh8_11 fn8_11 fn8_12 0.019765
rfrv8_11 fn8_11 fn9_11 0.063423
rfrh8_12 fn8_12 fn8_13 0.49729
rfrv8_12 fn8_12 fn9_12 31.728
rfrv8_13 fn8_13 fn9_13 0.36733
rfrh9_0 fn9_0 fn9_1 0.75078
rfrv9_0 fn9_0 fn10_0 5.9875
rfrh9_1 fn9_1 fn9_2 40.414
rfrv9_1 fn9_1 fn10_1 0.12894
rfrh9_2 fn9_2 fn9_3 0.011383
rfrv9_2 fn9_2 fn10_2 3.8191
rfrh9_3 fn9_3 fn9_4 0.043194
rfrv9_3 fn9_3 fn10_3 25.617
rfrh9_4 fn9_4 fn9_5 12.395
rfrv9_4 fn9_4 fn10_4 0.012598
rfrh9_5 fn9_5 fn9_6 0.44806
rfrv9_5 fn9_5 fn10_5 0.061961
rfrh9_6 fn9_6 fn9_7 68.951
rfrv9_6 fn9_6 fn10_6 85.972
rfrh9_7 fn9_7 fn9_8 2.8234
rfrv9_7 fn9_7 fn10_7 14.586
rfrh9_8 fn9_8 fn9_9 12.83
rfrv9_8 fn9_8 fn10_8 0.040898
rfrh9_9 fn9_9 fn9_10 26.512
rfrv9_9 fn9_9 fn10_9 19.629
rfrh9_10 fn9_10 fn9_11 2.5001
rfrv9_10 fn9_10 fn10_10 7.3621
rfrh9_11 fn9_11 fn9_12 0.042028
rfrv9_11 fn9_11 fn10_11 0.16336
rfrh9_12 fn9_12 fn9_13 2.3261
rfrv9_12 fn9_12 fn10_12 8.7872
rfrv9_13 fn9_13 fn10_13 1.2153
rfrh10_0 fn10_0 fn10_1 44.238
rfrv10_0 fn10_0 fn11_0 0.096877
rfrh10_1 fn10_1 fn10_2 0.32063
rfrv10_1 fn10_1 fn11_1 0.085631
rfrh10_2 fn10_2 fn10_3 3.604
rfrv10_2 fn10_2 fn11_2 0.01349
rfrh10_3 fn10_3 fn10_4 1.1105
rfrv10_3 fn10_3 fn11_3 50.037
rfrh10_4 fn10_4 fn10_5 3.4545
rfrv10_4 fn10_4 fn11_4 8.0998
rfrh10_5 fn10_5 fn10_6 0.047063
rfrv10_5 fn10_5 fn11_5 1.8334
rfrh10_6 fn10_6 fn10_7 1.4066
rfrv10_6 fn10_6 fn11_6 4.7506
rfrh10_7 fn10_7 fn10_8 22.016
rfrv10_7 fn10_7 fn11_7 2.1985
rfrh10_8 fn10_8 fn10_9 85.557
rfrv10_8 fn10_8 fn11_8 0.45874
rfrh10_9 fn10_9 fn10_10 0.018468
rfrv10_9 fn10_9 fn11_9 0.16103
rfrh10_10 fn10_10 fn10_11 1.2731
rfrv10_10 fn10_10 fn11_10 0.6574
rfrh10_11 fn10_11 fn10_12 26.855
rfrv10_11 fn10_11 fn11_11 0.121
rfrh10_12 fn10_12 fn10_13 0.19653
rfrv10_12 fn10_12 fn11_12 0.43759
rfrv10_13 fn10_13 fn11_13 0.20597
rfrh11_0 fn11_0 fn11_1 0.023812
rfrv11_0 fn11_0 fn12_0 0.10715
rfrh11_1 fn11_1 fn11_2 1.3
rfrv11_1 fn11_1 fn12_1 23.101
rfrh11_2 fn11_2 fn11_3 0.018708
rfrv11_2 fn11_2 fn12_2 0.097078
rfrh11_3 fn11_3 fn11_4 57.434
rfrv11_3 fn11_3 fn12_3 0.014227
rfrh11_4 fn11_4 fn11_5 88.777
rfrv11_4 fn11_4 fn12_4 35.224
rfrh11_5 fn11_5 fn11_6 0.097924
rfrv11_5 fn11_5 fn12_5 0.030583
rfrh11_6 fn11_6 fn11_7 0.048549
rfrv11_6 fn11_6 fn12_6 0.012701
rfrh11_7 fn11_7 fn11_8 0.012244
rfrv11_7 fn11_7 fn12_7 0.98937
rfrh11_8 fn11_8 fn11_9 0.010151
rfrv11_8 fn11_8 fn12_8 1.0946
rfrh11_9 fn11_9 fn11_10 33.567
rfrv11_9 fn11_9 fn12_9 1.1284
rfrh11_10 fn11_10 fn11_11 0.3389
rfrv11_10 fn11_10 fn12_10 18.839
rfrh11_11 fn11_11 fn11_12 0.23682
rfrv11_11 fn11_11 fn12_11 11.573
rfrh11_12 fn11_12 fn11_13 0.013642
rfrv11_12 fn11_12 fn12_12 0.019446
rfrv11_13 fn11_13 fn12_13 66.452
rfrh12_0 fn12_0 fn12_1 0.045887
rfrv12_0 fn12_0 fn13_0 9.1947
rfrh12_1 fn12_1 fn12_2 26.493
rfrv12_1 fn12_1 fn13_1 0.034554
rfrh12_2 fn12_2 fn12_3 41.919
rfrv12_2 fn12_2 fn13_2 5.2951
rfrh12_3 fn12_3 fn12_4 0.014956
rfrv12_3 fn12_3 fn13_3 0.17365
rfrh12_4 fn12_4 fn12_5 0.30346
rfrv12_4 fn12_4 fn13_4 0.049829
rfrh12_5 fn12_5 fn12_6 1.1352
rfrv12_5 fn12_5 fn13_5 55.118
rfrh12_6 fn12_6 fn12_7 0.62125
rfrv12_6 fn12_6 fn13_6 0.93914
rfrh12_7 fn12_7 fn12_8 0.28286
rfrv12_7 fn12_7 fn13_7 0.45716
rfrh12_8 fn12_8 fn12_9 0.012854
rfrv12_8 fn12_8 fn13_8 13.526
rfrh12_9 fn12_9 fn12_10 0.45196
rfrv12_9 fn12_9 fn13_9 1.6401
rfrh12_10 fn12_10 fn12_11 0.18978
rfrv12_10 fn12_10 fn13_10 28
rfrh12_11 fn12_11 fn12_12 0.019762
rfrv12_11 fn12_11 fn13_11 2.9465
rfrh12_12 fn12_12 fn12_13 0.019322
rfrv12_12 fn12_12 fn13_12 0.24656
rfrv12_13 fn12_13 fn13_13 0.081712
rfrh13_0 fn13_0 fn13_1 0.11402
rfrh13_1 fn13_1 fn13_2 0.16974
rfrh13_2 fn13_2 fn13_3 76.296
rfrh13_3 fn13_3 fn13_4 86.831
rfrh13_4 fn13_4 fn13_5 23.337
rfrh13_5 fn13_5 fn13_6 45.065
rfrh13_6 fn13_6 fn13_7 0.012011
rfrh13_7 fn13_7 fn13_8 30.255
rfrh13_8 fn13_8 fn13_9 0.026531
rfrh13_9 fn13_9 fn13_10 60.089
rfrh13_10 fn13_10 fn13_11 2.717
rfrh13_11 fn13_11 fn13_12 49.3
rfrh13_12 fn13_12 fn13_13 0.042969
rfp0 fp1 fn0_0 0.01
rfp1 fn0_13 0 0.01
rfp2 fn13_0 0 0.01
rfp3 fp2 fn13_13 0.01
vf1 fp1 0 DC 1.0
vf2 fp2 0 DC -0.7
if3 0 fn7_4 DC 0.5
rarh0_0 an0_0 an0_1 0.07949
rarv0_0 an0_0 an1_0 0.043191
rarh0_1 an0_1 an0_2 0.028901
rarv0_1 an0_1 an1_1 0.77446
rarh0_2 an0_2 an0_3 2.1612
rarv0_2 an0_2 an1_2 0.05834
rarh0_3 an0_3 an0_4 0.16298
rarv0_3 an0_3 an1_3 21.178
rarh0_4 an0_4 an0_5 5.4182
rarv0_4 an0_4 an1_4 2.4593
rarh0_5 an0_5 an0_6 0.46846
rarv0_5 an0_5 an1_5 4.968
rarh0_6 an0_6 an0_7 0.02753
rarv0_6 an0_6 an1_6 0.13939
rarh0_7 an0_7 an0_8 6.0318
rarv0_7 an0_7 an1_7 60.963
rarh0_8 an0_8 an0_9 0.21165
rarv0_8 an0_8 an1_8 1.6668
rarh0_9 an0_9 an0_10 0.010995
rarv0_9 an0_9 an1_9 0.023165
rarh0_10 an0_10 an0_11 16.849
rarv0_10 an0_10 an1_10 10.344
rarh0_11 an0_11 an0_12 2.5996
rarv0_11 an0_11 an1_11 3.9229
rarh0_12 an0_12 an0_13 0.011808
rarv0_12 an0_12 an1_12 0.19891
rarv0_13 an0_13 an1_13 34.492
rarh1_0 an1_0 an1_1 13.64
rarv1_0 an1_0 an2_0 0.024922
rarh1_1 an1_1 an1_2 0.13267
rarv1_1 an1_1 an2_1 0.40219
rarh1_2 an1_2 an1_3 1.7994
rarv1_2 an1_2 an2_2 0.26296
rarh1_3 an1_3 an1_4 0.38977
rarv1_3 an1_3 an2_3 1.202
rarh1_4 an1_4 an1_5 0.30597
rarv1_4 an1_4 an2_4 0.23269
rarh1_5 an1_5 an1_6 0.031318
rarv1_5 an1_5 an2_5 1.0647
rarh1_6 an1_6 an1_7 6.0872
rarv1_6 an1_6 an2_6 0.25332
rarh1_7 an1_7 an1_8 3.5917
rarv1_7 an1_7 an2_7 0.85048
rarh1_8 an1_8 an1_9 0.6922
rarv1_8 an1_8 an2_8 45.621
rarh1_9 an1_9 an1_10 0.71431
rarv1_9 an1_9 an2_9 0.13417
rarh1_10 an1_10 an1_11 0.013207
rarv1_10 an1_10 an2_10 0.54203
rarh1_11 an1_11 an1_12 5.5036
rarv1_11 an1_11 an2_11 5.0865
rarh1_12 an1_12 an1_13 10.943
rarv1_12 an1_12 an2_12 1.2935
rarv1_13 an1_13 an2_13 34.522
rarh2_0 an2_0 an2_1 0.13683
rarv2_0 an2_0 an3_0 0.14296
rarh2_1 an2_1 an2_2 0.020727
rarv2_1 an2_1 an3_1 0.29661
rarh2_2 an2_2 an2_3 69.16
rarv2_2 an2_2 an3_2 0.013871
rarh2_3 an2_3 an2_4 0.38808
rarv2_3 an2_3 an3_3 0.72185
rarh2_4 an2_4 an2_5 82.573
rarv2_4 an2_4 an3_4 0.016368
rarh2_5 an2_5 an2_6 34.725
rarv2_5 an2_5 an3_5 15.726
rarh2_6 an2_6 an2_7 40.729
rarv2_6 an2_6 an3_6 0.1815
rarh2_7 an2_7 an2_8 0.339
rarv2_7 an2_7 an3_7 80.753
rarh2_8 an2_8 an2_9 0.17824
rarv2_8 an2_8 an3_8 0.015231
rarh2_9 an2_9 an2_10 0.26242
rarv2_9 an2_9 an3_9 2.1893
rarh2_10 an2_10 an2_11 0.039898
rarv2_10 an2_10 an3_10 65.903
rarh2_11 an2_11 an2_12 6.0463
rarv2_11 an2_11 an3_11 1.712
rarh2_12 an2_12 an2_13 7.8001
rarv2_12 an2_12 an3_12 0.41694
rarv2_13 an2_13 an3_13 1.8557
rarh3_0 an3_0 an3_1 0.12409
rarv3_0 an3_0 an4_0 68.908
rarh3_1 an3_1 an3_2 0.40098
rarv3_1 an3_1 an4_1 0.015704
rarh3_2 an3_2 an3_3 2.9761
rarv3_2 an3_2 an4_2 4.1782
rarh3_3 an3_3 an3_4 32.687
rarv3_3 an3_3 an4_3 10.885
rarh3_4 an3_4 an3_5 92.17
rarv3_4 an3_4 an4_4 0.5774
rarh3_5 an3_5 an3_6 14.271
rarv3_5 an3_5 an4_5 0.025447
rarh3_6 an3_6 an3_7 0.011217
rarv3_6 an3_6 an4_6 57.129
rarh3_7 an3_7 an3_8 5.6204
rarv3_7 an3_7 an4_7 12.873
rarh3_8 an3_8 an3_9 66.15
rarv3_8 an3_8 an4_8 4.167
rarh3_9 an3_9 an3_10 29.546
rarv3_9 an3_9 an4_9 11.991
rarh3_10 an3_10 an3_11 0.84034
rarv3_10 an3_10 an4_10 1.5378
rarh3_11 an3_11 an3_12 0.77671
rarv3_11 an3_11 an4_11 0.97199
rarh3_12 an3_12 an3_13 0.031234
rarv3_12 an3_12 an4_12 48.476
rarv3_13 an3_13 an4_13 1.6643
rarh4_0 an4_0 an4_1 7.9116
rarv4_0 an4_0 an5_0 0.40806
rarh4_1 an4_1 an4_2 0.04472
rarv4_1 an4_1 an5_1 4.545
rarh4_2 an4_2 an4_3 0.034361
rarv4_2 an4_2 an5_2 36.836
rarh4_3 an4_3 an4_4 26.16
rarv4_3 an4_3 an5_3 0.20188
rarh4_4 an4_4 an4_5 0.62895
rarv4_4 an4_4 an5_4 2.3787
rarh4_5 an4_5 an4_6 0.012442
rarv4_5 an4_5 an5_5 0.019225
rarh4_6 an4_6 an4_7 18.08
rarv4_6 an4_6 an5_6 6.437
rarh4_7 an4_7 an4_8 0.018971
rarv4_7 an4_7 an5_7 0.24233
rarh4_8 an4_8 an4_9 7.7019
rarv4_8 an4_8 an5_8 0.17618
rarh4_9 an4_9 an4_10 0.015317
rarv4_9 an4_9 an5_9 1.8787
rarh4_10 an4_10 an4_11 19.61
rarv4_10 an4_10 an5_10 1.0689
rarh4_11 an4_11 an4_12 0.2415
rarv4_11 an4_11 an5_11 0.46929
rarh4_12 an4_12 an4_13 0.89046
rarv4_12 an4_12 an5_12 13.198
rarv4_13 an4_13 an5_13 4.9925
rarh5_0 an5_0 an5_1 23
rarv5_0 an5_0 an6_0 0.25447
rarh5_1 an5_1 an5_2 0.019077
rarv5_1 an5_1 an6_1 0.040085
rarh5_2 an5_2 an5_3 9.1707
rarv5_2 an5_2 an6_2 36.957
rarh5_3 an5_3 an5_4 36.669
rarv5_3 an5_3 an6_3 3.7385
rarh5_4 an5_4 an5_5 0.13621
rarv5_4 an5_4 an6_4 0.37056
rarh5_5 an5_5 an5_6 2.2891
rarv5_5 an5_5 an6_5 35.826
rarh5_6 an5_6 an5_7 63.361
rarv5_6 an5_6 an6_6 38.612
rarh5_7 an5_7 an5_8 29.633
rarv5_7 an5_7 an6_7 0.67233
rarh5_8 an5_8 an5_9 4.1311
rarv5_8 an5_8 an6_8 1.4558
rarh5_9 an5_9 an5_10 9.9609
rarv5_9 an5_9 an6_9 1.6093
rarh5_10 an5_10 an5_11 0.67203
rarv5_10 an5_10 an6_10 6.2123
rarh5_11 an5_11 an5_12 40.961
rarv5_11 an5_11 an6_11 9.9189
rarh5_12 an5_12 an5_13 0.022801
rarv5_12 an5_12 an6_12 7.8165
rarv5_13 an5_13 an6_13 0.20934
rarh6_0 an6_0 an6_1 0.36185
rarv6_0 an6_0 an7_0 0.030169
rarh6_1 an6_1 an6_2 0.39251
rarv6_1 an6_1 an7_1 0.02581
rarh6_2 an6_2 an6_3 3.5432
rarv6_2 an6_2 an7_2 5.7127
rarh6_3 an6_3 an6_4 24.462
rarv6_3 an6_3 an7_3 0.47624
rarh6_4 an6_4 an6_5 1.2544
rarv6_4 an6_4 an7_4 0.015166
rarh6_5 an6_5 an6_6 15.202
rarv6_5 an6_5 an7_5 1.0369
rarh6_6 an6_6 an6_7 68.81
rarv6_6 an6_6 an7_6 3.4048
rarh6_7 an6_7 an6_8 15.495
rarv6_7 an6_7 an7_7 0.6625
rarh6_8 an6_8 an6_9 0.35928
rarv6_8 an6_8 an7_8 0.20089
rarh6_9 an6_9 an6_10 38.517
rarv6_9 an6_9 an7_9 41.402
rarh6_10 an6_10 an6_11 0.010792
rarv6_10 an6_10 an7_10 3.86
rarh6_11 an6_11 an6_12 0.63189
rarv6_11 an6_11 an7_11 35.075
rarh6_12 an6_12 an6_13 25.152
rarv6_12 an6_12 an7_12 0.41562
rarv6_13 an6_13 an7_13 31.334
rarh7_0 an7_0 an7_1 0.075579
rarv7_0 an7_0 an8_0 76
rarh7_1 an7_1 an7_2 0.32575
rarv7_1 an7_1 an8_1 2.6932
rarh7_2 an7_2 an7_3 54.979
rarv7_2 an7_2 an8_2 0.36634
rarh7_3 an7_3 an7_4 55.475
rarv7_3 an7_3 an8_3 5.7295
rarh7_4 an7_4 an7_5 0.13068
rarv7_4 an7_4 an8_4 8.8078
rarh7_5 an7_5 an7_6 0.65371
rarv7_5 an7_5 an8_5 0.015192
rarh7_6 an7_6 an7_7 0.015676
rarv7_6 an7_6 an8_6 0.013824
rarh7_7 an7_7 an7_8 5.5302
rarv7_7 an7_7 an8_7 0.073462
rarh7_8 an7_8 an7_9 0.1036
rarv7_8 an7_8 an8_8 0.45409
rarh7_9 an7_9 an7_10 0.074468
rarv7_9 an7_9 an8_9 0.18253
rarh7_10 an7_10 an7_11 0.247
rarv7_10 an7_10 an8_10 0.12481
rarh7_11 an7_11 an7_12 10.966
rarv7_11 an7_11 an8_11 0.072396
rarh7_12 an7_12 an7_13 72.642
rarv7_12 an7_12 an8_12 0.10097
rarv7_13 an7_13 an8_13 5.9482
rarh8_0 an8_0 an8_1 0.12867
rarv8_0 an8_0 an9_0 0.27021
rarh8_1 an8_1 an8_2 0.019452
rarv8_1 an8_1 an9_1 0.078267
rarh8_2 an8_2 an8_3 5.2072
rarv8_2 an8_2 an9_2 0.010993
rarh8_3 an8_3 an8_4 0.3659
rarv8_3 an8_3 an9_3 1.8531
rarh8_4 an8_4 an8_5 0.28307
rarv8_4 an8_4 an9_4 0.012207
rarh8_5 an8_5 an8_6 1.601
rarv8_5 an8_5 an9_5 1.6014
rarh8_6 an8_6 an8_7 0.38778
rarv8_6 an8_6 an9_6 0.14101
rarh8_7 an8_7 an8_8 0.025189
rarv8_7 an8_7 an9_7 0.31118
rarh8_8 an8_8 an8_9 0.11865
rarv8_8 an8_8 an9_8 91.926
rarh8_9 an8_9 an8_10 37.363
rarv8_9 an8_9 an9_9 0.017907
rarh8_10 an8_10 an8_11 50.476
rarv8_10 an8_10 an9_10 0.048368
rarh8_11 an8_11 an8_12 0.019765
rarv8_11 an8_11 an9_11 0.063423
rarh8_12 an8_12 an8_13 0.49729
rarv8_12 an8_12 an9_12 31.728
rarv8_13 an8_13 an9_13 0.36733
rarh9_0 an9_0 an9_1 0.75078
rarv9_0 an9_0 an10_0 5.9875
rarh9_1 an9_1 an9_2 40.414
rarv9_1 an9_1 an10_1 0.12894
rarh9_2 an9_2 an9_3 0.011383
rarv9_2 an9_2 an10_2 3.8191
rarh9_3 an9_3 an9_4 0.043194
rarv9_3 an9_3 an10_3 25.617
rarh9_4 an9_4 an9_5 12.395
rarv9_4 an9_4 an10_4 0.012598
rarh9_5 an9_5 an9_6 0.44806
rarv9_5 an9_5 an10_5 0.061961
rarh9_6 an9_6 an9_7 68.951
rarv9_6 an9_6 an10_6 85.972
rarh9_7 an9_7 an9_8 2.8234
rarv9_7 an9_7 an10_7 14.586
rarh9_8 an9_8 an9_9 12.83
rarv9_8 an9_8 an10_8 0.040898
rarh9_9 an9_9 an9_10 26.512
rarv9_9 an9_9 an10_9 19.629
rarh9_10 an9_10 an9_11 2.5001
rarv9_10 an9_10 an10_10 7.3621
rarh9_11 an9_11 an9_12 0.042028
rarv9_11 an9_11 an10_11 0.16336
rarh9_12 an9_12 an9_13 2.3261
rarv9_12 an9_12 an10_12 8.7872
rarv9_13 an9_13 an10_13 1.2153
rarh10_0 an10_0 an10_1 44.238
rarv10_0 an10_0 an11_0 0.096877
rarh10_1 an10_1 an10_2 0.32063
rarv10_1 an10_1 an11_1 0.085631
rarh10_2 an10_2 an10_3 3.604
rarv10_2 an10_2 an11_2 0.01349
rarh10_3 an10_3 an10_4 1.1105
rarv10_3 an10_3 an11_3 50.037
rarh10_4 an10_4 an10_5 3.4545
rarv10_4 an10_4 an11_4 8.0998
rarh10_5 an10_5 an10_6 0.047063
rarv10_5 an10_5 an11_5 1.8334
rarh10_6 an10_6 an10_7 1.4066
rarv10_6 an10_6 an11_6 4.7506
rarh10_7 an10_7 an10_8 22.016
rarv10_7 an10_7 an11_7 2.1985
rarh10_8 an10_8 an10_9 85.557
rarv10_8 an10_8 an11_8 0.45874
rarh10_9 an10_9 an10_10 0.018468
rarv10_9 an10_9 an11_9 0.16103
rarh10_10 an10_10 an10_11 1.2731
rarv10_10 an10_10 an11_10 0.6574
rarh10_11 an10_11 an10_12 26.855
rarv10_11 an10_11 an11_11 0.121
rarh10_12 an10_12 an10_13 0.19653
rarv10_12 an10_12 an11_12 0.43759
rarv10_13 an10_13 an11_13 0.20597
rarh11_0 an11_0 an11_1 0.023812
rarv11_0 an11_0 an12_0 0.10715
rarh11_1 an11_1 an11_2 1.3
rarv11_1 an11_1 an12_1 23.101
rarh11_2 an11_2 an11_3 0.018708
rarv11_2 an11_2 an12_2 0.097078
rarh11_3 an11_3 an11_4 57.434
rarv11_3 an11_3 an12_3 0.014227
rarh11_4 an11_4 an11_5 88.777
rarv11_4 an11_4 an12_4 35.224
rarh11_5 an11_5 an11_6 0.097924
rarv11_5 an11_5 an12_5 0.030583
rarh11_6 an11_6 an11_7 0.048549
rarv11_6 an11_6 an12_6 0.012701
rarh11_7 an11_7 an11_8 0.012244
rarv11_7 an11_7 an12_7 0.98937
rarh11_8 an11_8 an11_9 0.010151
rarv11_8 an11_8 an12_8 1.0946
rarh11_9 an11_9 an11_10 33.567
rarv11_9 an11_9 an12_9 1.1284
rarh11_10 an11_10 an11_11 0.3389
rarv11_10 an11_10 an12_10 18.839
rarh11_11 an11_11 an11_12 0.23682
rarv11_11 an11_11 an12_11 11.573
rarh11_12 an11_12 an11_13 0.013642
rarv11_12 an11_12 an12_12 0.019446
rarv11_13 an11_13 an12_13 66.452
rarh12_0 an12_0 an12_1 0.045887
rarv12_0 an12_0 an13_0 9.1947
rarh12_1 an12_1 an12_2 26.493
rarv12_1 an12_1 an13_1 0.034554
rarh12_2 an12_2 an12_3 41.919
rarv12_2 an12_2 an13_2 5.2951
rarh12_3 an12_3 an12_4 0.014956
rarv12_3 an12_3 an13_3 0.17365
rarh12_4 an12_4 an12_5 0.30346
rarv12_4 an12_4 an13_4 0.049829
rarh12_5 an12_5 an12_6 1.1352
rarv12_5 an12_5 an13_5 55.118
rarh12_6 an12_6 an12_7 0.62125
rarv12_6 an12_6 an13_6 0.93914
rarh12_7 an12_7 an12_8 0.28286
rarv12_7 an12_7 an13_7 0.45716
rarh12_8 an12_8 an12_9 0.012854
rarv12_8 an12_8 an13_8 13.526
rarh12_9 an12_9 an12_10 0.45196
rarv12_9 an12_9 an13_9 1.6401
rarh12_10 an12_10 an12_11 0.18978
rarv12_10 an12_10 an13_10 28
rarh12_11 an12_11 an12_12 0.019762
rarv12_11 an12_11 an13_11 2.9465
rarh12_12 an12_12 an12_13 0.019322
rarv12_12 an12_12 an13_12 0.24656
rarv12_13 an12_13 an13_13 0.081712
rarh13_0 an13_0 an13_1 0.11402
rarh13_1 an13_1 an13_2 0.16974
rarh13_2 an13_2 an13_3 76.296
rarh13_3 an13_3 an13_4 86.831
rarh13_4 an13_4 an13_5 23.337
rarh13_5 an13_5 an13_6 45.065
rarh13_6 an13_6 an13_7 0.012011
rarh13_7 an13_7 an13_8 30.255
rarh13_8 an13_8 an13_9 0.026531
rarh13_9 an13_9 an13_10 60.089
rarh13_10 an13_10 an13_11 2.717
rarh13_11 an13_11 an13_12 49.3
rarh13_12 an13_12 an13_13 0.042969
rap0 ap1 an0_0 0.01
rap1 an0_13 0 0.01
rap2 an13_0 0 0.01
rap3 ap2 an13_13 0.01
va1 ap1 0 DC 1.0
va2 ap2 0 DC 0
ia3 0 an7_4 DC 0
rbrh0_0 bn0_0 bn0_1 0.07949
rbrv0_0 bn0_0 bn1_0 0.043191
rbrh0_1 bn0_1 bn0_2 0.028901
rbrv0_1 bn0_1 bn1_1 0.77446
rbrh0_2 bn0_2 bn0_3 2.1612
rbrv0_2 bn0_2 bn1_2 0.05834
rbrh0_3 bn0_3 bn0_4 0.16298
rbrv0_3 bn0_3 bn1_3 21.178
rbrh0_4 bn0_4 bn0_5 5.4182
rbrv0_4 bn0_4 bn1_4 2.4593
rbrh0_5 bn0_5 bn0_6 0.46846
rbrv0_5 bn0_5 bn1_5 4.968
rbrh0_6 bn0_6 bn0_7 0.02753
rbrv0_6 bn0_6 bn1_6 0.13939
rbrh0_7 bn0_7 bn0_8 6.0318
rbrv0_7 bn0_7 bn1_7 60.963
rbrh0_8 bn0_8 bn0_9 0.21165
rbrv0_8 bn0_8 bn1_8 1.6668
rbrh0_9 bn0_9 bn0_10 0.010995
rbrv0_9 bn0_9 bn1_9 0.023165
rbrh0_10 bn0_10 bn0_11 16.849
rbrv0_10 bn0_10 bn1_10 10.344
rbrh0_11 bn0_11 bn0_12 2.5996
rbrv0_11 bn0_11 bn1_11 3.9229
rbrh0_12 bn0_12 bn0_13 0.011808
rbrv0_12 bn0_12 bn1_12 0.19891
rbrv0_13 bn0_13 bn1_13 34.492
rbrh1_0 bn1_0 bn1_1 13.64
rbrv1_0 bn1_0 bn2_0 0.024922
rbrh1_1 bn1_1 bn1_2 0.13267
rbrv1_1 bn1_1 bn2_1 0.40219
rbrh1_2 bn1_2 bn1_3 1.7994
rbrv1_2 bn1_2 bn2_2 0.26296
rbrh1_3 bn1_3 bn1_4 0.38977
rbrv1_3 bn1_3 bn2_3 1.202
rbrh1_4 bn1_4 bn1_5 0.30597
rbrv1_4 bn1_4 bn2_4 0.23269
rbrh1_5 bn1_5 bn1_6 0.031318
rbrv1_5 bn1_5 bn2_5 1.0647
rbrh1_6 bn1_6 bn1_7 6.0872
rbrv1_6 bn1_6 bn2_6 0.25332
rbrh1_7 bn1_7 bn1_8 3.5917
rbrv1_7 bn1_7 bn2_7 0.85048
rbrh1_8 bn1_8 bn1_9 0.6922
rbrv1_8 bn1_8 bn2_8 45.621
rbrh1_9 bn1_9 bn1_10 0.71431
rbrv1_9 bn1_9 bn2_9 0.13417
rbrh1_10 bn1_10 bn1_11 0.013207
rbrv1_10 bn1_10 bn2_10 0.54203
rbrh1_11 bn1_11 bn1_12 5.5036
rbrv1_11 bn1_11 bn2_11 5.0865
rbrh1_12 bn1_12 bn1_13 10.943
rbrv1_12 bn1_12 bn2_12 1.2935
rbrv1_13 bn1_13 bn2_13 34.522
rbrh2_0 bn2_0 bn2_1 0.13683
rbrv2_0 bn2_0 bn3_0 0.14296
rbrh2_1 bn2_1 bn2_2 0.020727
rbrv2_1 bn2_1 bn3_1 0.29661
rbrh2_2 bn2_2 bn2_3 69.16
rbrv2_2 bn2_2 bn3_2 0.013871
rbrh2_3 bn2_3 bn2_4 0.38808
rbrv2_3 bn2_3 bn3_3 0.72185
rbrh2_4 bn2_4 bn2_5 82.573
rbrv2_4 bn2_4 bn3_4 0.016368
rbrh2_5 bn2_5 bn2_6 34.725
rbrv2_5 bn2_5 bn3_5 15.726
rbrh2_6 bn2_6 bn2_7 40.729
rbrv2_6 bn2_6 bn3_6 0.1815
rbrh2_7 bn2_7 bn2_8 0.339
rbrv2_7 bn2_7 bn3_7 80.753
rbrh2_8 bn2_8 bn2_9 0.17824
rbrv2_8 bn2_8 bn3_8 0.015231
rbrh2_9 bn2_9 bn2_10 0.26242
rbrv2_9 bn2_9 bn3_9 2.1893
rbrh2_10 bn2_10 bn2_11 0.039898
rbrv2_10 bn2_10 bn3_10 65.903
rbrh2_11 bn2_11 bn2_12 6.0463
rbrv2_11 bn2_11 bn3_11 1.712
rbrh2_12 bn2_12 bn2_13 7.8001
rbrv2_12 bn2_12 bn3_12 0.41694
rbrv2_13 bn2_13 bn3_13 1.8557
rbrh3_0 bn3_0 bn3_1 0.12409
rbrv3_0 bn3_0 bn4_0 68.908
rbrh3_1 bn3_1 bn3_2 0.40098
rbrv3_1 bn3_1 bn4_1 0.015704
rbrh3_2 bn3_2 bn3_3 2.9761
rbrv3_2 bn3_2 bn4_2 4.1782
rbrh3_3 bn3_3 bn3_4 32.687
rbrv3_3 bn3_3 bn4_3 10.885
rbrh3_4 bn3_4 bn3_5 92.17
rbrv3_4 bn3_4 bn4_4 0.5774
rbrh3_5 bn3_5 bn3_6 14.271
rbrv3_5 bn3_5 bn4_5 0.025447
rbrh3_6 bn3_6 bn3_7 0.011217
rbrv3_6 bn3_6 bn4_6 57.129
rbrh3_7 bn3_7 bn3_8 5.6204
rbrv3_7 bn3_7 bn4_7 12.873
rbrh3_8 bn3_8 bn3_9 66.15
rbrv3_8 bn3_8 bn4_8 4.167
rbrh3_9 bn3_9 bn3_10 29.546
rbrv3_9 bn3_9 bn4_9 11.991
rbrh3_10 bn3_10 bn3_11 0.84034
rbrv3_10 bn3_10 bn4_10 1.5378
rbrh3_11 bn3_11 bn3_12 0.77671
rbrv3_11 bn3_11 bn4_11 0.97199
rbrh3_12 bn3_12 bn3_13 0.031234
rbrv3_12 bn3_12 bn4_12 48.476
rbrv3_13 bn3_13 bn4_13 1.6643
rbrh4_0 bn4_0 bn4_1 7.9116
rbrv4_0 bn4_0 bn5_0 0.40806
rbrh4_1 bn4_1 bn4_2 0.04472
rbrv4_1 bn4_1 bn5_1 4.545
rbrh4_2 bn4_2 bn4_3 0.034361
rbrv4_2 bn4_2 bn5_2 36.836
rbrh4_3 bn4_3 bn4_4 26.16
rbrv4_3 bn4_3 bn5_3 0.20188
rbrh4_4 bn4_4 bn4_5 0.62895
rbrv4_4 bn4_4 bn5_4 2.3787
rbrh4_5 bn4_5 bn4_6 0.012442
rbrv4_5 bn4_5 bn5_5 0.019225
rbrh4_6 bn4_6 bn4_7 18.08
rbrv4_6 bn4_6 bn5_6 6.437
rbrh4_7 bn4_7 bn4_8 0.018971
rbrv4_7 bn4_7 bn5_7 0.24233
rbrh4_8 bn4_8 bn4_9 7.7019
rbrv4_8 bn4_8 bn5_8 0.17618
rbrh4_9 bn4_9 bn4_10 0.015317
rbrv4_9 bn4_9 bn5_9 1.8787
rbrh4_10 bn4_10 bn4_11 19.61
rbrv4_10 bn4_10 bn5_10 1.0689
rbrh4_11 bn4_11 bn4_12 0.2415
rbrv4_11 bn4_11 bn5_11 0.46929
rbrh4_12 bn4_12 bn4_13 0.89046
rbrv4_12 bn4_12 bn5_12 13.198
rbrv4_13 bn4_13 bn5_13 4.9925
rbrh5_0 bn5_0 bn5_1 23
rbrv5_0 bn5_0 bn6_0 0.25447
rbrh5_1 bn5_1 bn5_2 0.019077
rbrv5_1 bn5_1 bn6_1 0.040085
rbrh5_2 bn5_2 bn5_3 9.1707
rbrv5_2 bn5_2 bn6_2 36.957
rbrh5_3 bn5_3 bn5_4 36.669
rbrv5_3 bn5_3 bn6_3 3.7385
rbrh5_4 bn5_4 bn5_5 0.13621
rbrv5_4 bn5_4 bn6_4 0.37056
rbrh5_5 bn5_5 bn5_6 2.2891
rbrv5_5 bn5_5 bn6_5 35.826
rbrh5_6 bn5_6 bn5_7 63.361
rbrv5_6 bn5_6 bn6_6 38.612
rbrh5_7 bn5_7 bn5_8 29.633
rbrv5_7 bn5_7 bn6_7 0.67233
rbrh5_8 bn5_8 bn5_9 4.1311
rbrv5_8 bn5_8 bn6_8 1.4558
rbrh5_9 bn5_9 bn5_10 9.9609
rbrv5_9 bn5_9 bn6_9 1.6093
rbrh5_10 bn5_10 bn5_11 0.67203
rbrv5_10 bn5_10 bn6_10 6.2123
rbrh5_11 bn5_11 bn5_12 40.961
rbrv5_11 bn5_11 bn6_11 9.9189
rbrh5_12 bn5_12 bn5_13 0.022801
rbrv5_12 bn5_12 bn6_12 7.8165
rbrv5_13 bn5_13 bn6_13 0.20934
rbrh6_0 bn6_0 bn6_1 0.36185
rbrv6_0 bn6_0 bn7_0 0.030169
rbrh6_1 bn6_1 bn6_2 0.39251
rbrv6_1 bn6_1 bn7_1 0.02581
rbrh6_2 bn6_2 bn6_3 3.5432
rbrv6_2 bn6_2 bn7_2 5.7127
rbrh6_3 bn6_3 bn6_4 24.462
rbrv6_3 bn6_3 bn7_3 0.47624
rbrh6_4 bn6_4 bn6_5 1.2544
rbrv6_4 bn6_4 bn7_4 0.015166
rbrh6_5 bn6_5 bn6_6 15.202
rbrv6_5 bn6_5 bn7_5 1.0369
rbrh6_6 bn6_6 bn6_7 68.81
rbrv6_6 bn6_6 bn7_6 3.4048
rbrh6_7 bn6_7 bn6_8 15.495
rbrv6_7 bn6_7 bn7_7 0.6625
rbrh6_8 bn6_8 bn6_9 0.35928
rbrv6_8 bn6_8 bn7_8 0.20089
rbrh6_9 bn6_9 bn6_10 38.517
rbrv6_9 bn6_9 bn7_9 41.402
rbrh6_10 bn6_10 bn6_11 0.010792
rbrv6_10 bn6_10 bn7_10 3.86
rbrh6_11 bn6_11 bn6_12 0.63189
rbrv6_11 bn6_11 bn7_11 35.075
rbrh6_12 bn6_12 bn6_13 25.152
rbrv6_12 bn6_12 bn7_12 0.41562
rbrv6_13 bn6_13 bn7_13 31.334
rbrh7_0 bn7_0 bn7_1 0.075579
rbrv7_0 bn7_0 bn8_0 76
rbrh7_1 bn7_1 bn7_2 0.32575
rbrv7_1 bn7_1 bn8_1 2.6932
rbrh7_2 bn7_2 bn7_3 54.979
rbrv7_2 bn7_2 bn8_2 0.36634
rbrh7_3 bn7_3 bn7_4 55.475
rbrv7_3 bn7_3 bn8_3 5.7295
rbrh7_4 bn7_4 bn7_5 0.13068
rbrv7_4 bn7_4 bn8_4 8.8078
rbrh7_5 bn7_5 bn7_6 0.65371
rbrv7_5 bn7_5 bn8_5 0.015192
rbrh7_6 bn7_6 bn7_7 0.015676
rbrv7_6 bn7_6 bn8_6 0.013824
rbrh7_7 bn7_7 bn7_8 5.5302
rbrv7_7 bn7_7 bn8_7 0.073462
rbrh7_8 bn7_8 bn7_9 0.1036
rbrv7_8 bn7_8 bn8_8 0.45409
rbrh7_9 bn7_9 bn7_10 0.074468
rbrv7_9 bn7_9 bn8_9 0.18253
rbrh7_10 bn7_10 bn7_11 0.247
rbrv7_10 bn7_10 bn8_10 0.12481
rbrh7_11 bn7_11 bn7_12 10.966
rbrv7_11 bn7_11 bn8_11 0.072396
rbrh7_12 bn7_12 bn7_13 72.642
rbrv7_12 bn7_12 bn8_12 0.10097
rbrv7_13 bn7_13 bn8_13 5.9482
rbrh8_0 bn8_0 bn8_1 0.12867
rbrv8_0 bn8_0 bn9_0 0.27021
rbrh8_1 bn8_1 bn8_2 0.019452
rbrv8_1 bn8_1 bn9_1 0.078267
rbrh8_2 bn8_2 bn8_3 5.2072
rbrv8_2 bn8_2 bn9_2 0.010993
rbrh8_3 bn8_3 bn8_4 0.3659
rbrv8_3 bn8_3 bn9_3 1.8531
rbrh8_4 bn8_4 bn8_5 0.28307
rbrv8_4 bn8_4 bn9_4 0.012207
rbrh8_5 bn8_5 bn8_6 1.601
rbrv8_5 bn8_5 bn9_5 1.6014
rbrh8_6 bn8_6 bn8_7 0.38778
rbrv8_6 bn8_6 bn9_6 0.14101
rbrh8_7 bn8_7 bn8_8 0.025189
rbrv8_7 bn8_7 bn9_7 0.31118
rbrh8_8 bn8_8 bn8_9 0.11865
rbrv8_8 bn8_8 bn9_8 91.926
rbrh8_9 bn8_9 bn8_10 37.363
rbrv8_9 bn8_9 bn9_9 0.017907
rbrh8_10 bn8_10 bn8_11 50.476
rbrv8_10 bn8_10 bn9_10 0.048368
rbrh8_11 bn8_11 bn8_12 0.019765
rbrv8_11 bn8_11 bn9_11 0.063423
rbrh8_12 bn8_12 bn8_13 0.49729
rbrv8_12 bn8_12 bn9_12 31.728
rbrv8_13 bn8_13 bn9_13 0.36733
rbrh9_0 bn9_0 bn9_1 0.75078
rbrv9_0 bn9_0 bn10_0 5.9875
rbrh9_1 bn9_1 bn9_2 40.414
rbrv9_1 bn9_1 bn10_1 0.12894
rbrh9_2 bn9_2 bn9_3 0.011383
rbrv9_2 bn9_2 bn10_2 3.8191
rbrh9_3 bn9_3 bn9_4 0.043194
rbrv9_3 bn9_3 bn10_3 25.617
rbrh9_4 bn9_4 bn9_5 12.395
rbrv9_4 bn9_4 bn10_4 0.012598
rbrh9_5 bn9_5 bn9_6 0.44806
rbrv9_5 bn9_5 bn10_5 0.061961
rbrh9_6 bn9_6 bn9_7 68.951
rbrv9_6 bn9_6 bn10_6 85.972
rbrh9_7 bn9_7 bn9_8 2.8234
rbrv9_7 bn9_7 bn10_7 14.586
rbrh9_8 bn9_8 bn9_9 12.83
rbrv9_8 bn9_8 bn10_8 0.040898
rbrh9_9 bn9_9 bn9_10 26.512
rbrv9_9 bn9_9 bn10_9 19.629
rbrh9_10 bn9_10 bn9_11 2.5001
rbrv9_10 bn9_10 bn10_10 7.3621
rbrh9_11 bn9_11 bn9_12 0.042028
rbrv9_11 bn9_11 bn10_11 0.16336
rbrh9_12 bn9_12 bn9_13 2.3261
rbrv9_12 bn9_12 bn10_12 8.7872
rbrv9_13 bn9_13 bn10_13 1.2153
rbrh10_0 bn10_0 bn10_1 44.238
rbrv10_0 bn10_0 bn11_0 0.096877
rbrh10_1 bn10_1 bn10_2 0.32063
rbrv10_1 bn10_1 bn11_1 0.085631
rbrh10_2 bn10_2 bn10_3 3.604
rbrv10_2 bn10_2 bn11_2 0.01349
rbrh10_3 bn10_3 bn10_4 1.1105
rbrv10_3 bn10_3 bn11_3 50.037
rbrh10_4 bn10_4 bn10_5 3.4545
rbrv10_4 bn10_4 bn11_4 8.0998
rbrh10_5 bn10_5 bn10_6 0.047063
rbrv10_5 bn10_5 bn11_5 1.8334
rbrh10_6 bn10_6 bn10_7 1.4066
rbrv10_6 bn10_6 bn11_6 4.7506
rbrh10_7 bn10_7 bn10_8 22.016
rbrv10_7 bn10_7 bn11_7 2.1985
rbrh10_8 bn10_8 bn10_9 85.557
rbrv10_8 bn10_8 bn11_8 0.45874
rbrh10_9 bn10_9 bn10_10 0.018468
rbrv10_9 bn10_9 bn11_9 0.16103
rbrh10_10 bn10_10 bn10_11 1.2731
rbrv10_10 bn10_10 bn11_10 0.6574
rbrh10_11 bn10_11 bn10_12 26.855
rbrv10_11 bn10_11 bn11_11 0.121
rbrh10_12 bn10_12 bn10_13 0.19653
rbrv10_12 bn10_12 bn11_12 0.43759
rbrv10_13 bn10_13 bn11_13 0.20597
rbrh11_0 bn11_0 bn11_1 0.023812
rbrv11_0 bn11_0 bn12_0 0.10715
rbrh11_1 bn11_1 bn11_2 1.3
rbrv11_1 bn11_1 bn12_1 23.101
rbrh11_2 bn11_2 bn11_3 0.018708
rbrv11_2 bn11_2 bn12_2 0.097078
rbrh11_3 bn11_3 bn11_4 57.434
rbrv11_3 bn11_3 bn12_3 0.014227
rbrh11_4 bn11_4 bn11_5 88.777
rbrv11_4 bn11_4 bn12_4 35.224
rbrh11_5 bn11_5 bn11_6 0.097924
rbrv11_5 bn11_5 bn12_5 0.030583
rbrh11_6 bn11_6 bn11_7 0.048549
rbrv11_6 bn11_6 bn12_6 0.012701
rbrh11_7 bn11_7 bn11_8 0.012244
rbrv11_7 bn11_7 bn12_7 0.98937
rbrh11_8 bn11_8 bn11_9 0.010151
rbrv11_8 bn11_8 bn12_8 1.0946
rbrh11_9 bn11_9 bn11_10 33.567
rbrv11_9 bn11_9 bn12_9 1.1284
rbrh11_10 bn11_10 bn11_11 0.3389
rbrv11_10 bn11_10 bn12_10 18.839
rbrh11_11 bn11_11 bn11_12 0.23682
rbrv11_11 bn11_11 bn12_11 11.573
rbrh11_12 bn11_12 bn11_13 0.013642
rbrv11_12 bn11_12 bn12_12 0.019446
rbrv11_13 bn11_13 bn12_13 66.452
rbrh12_0 bn12_0 bn12_1 0.045887
rbrv12_0 bn12_0 bn13_0 9.1947
rbrh12_1 bn12_1 bn12_2 26.493
rbrv12_1 bn12_1 bn13_1 0.034554
rbrh12_2 bn12_2 bn12_3 41.919
rbrv12_2 bn12_2 bn13_2 5.2951
rbrh12_3 bn12_3 bn12_4 0.014956
rbrv12_3 bn12_3 bn13_3 0.17365
rbrh12_4 bn12_4 bn12_5 0.30346
rbrv12_4 bn12_4 bn13_4 0.049829
rbrh12_5 bn12_5 bn12_6 1.1352
rbrv12_5 bn12_5 bn13_5 55.118
rbrh12_6 bn12_6 bn12_7 0.62125
rbrv12_6 bn12_6 bn13_6 0.93914
rbrh12_7 bn12_7 bn12_8 0.28286
rbrv12_7 bn12_7 bn13_7 0.45716
rbrh12_8 bn12_8 bn12_9 0.012854
rbrv12_8 bn12_8 bn13_8 13.526
rbrh12_9 bn12_9 bn12_10 0.45196
rbrv12_9 bn12_9 bn13_9 1.6401
rbrh12_10 bn12_10 bn12_11 0.18978
rbrv12_10 bn12_10 bn13_10 28
rbrh12_11 bn12_11 bn12_12 0.019762
rbrv12_11 bn12_11 bn13_11 2.9465
rbrh12_12 bn12_12 bn12_13 0.019322
rbrv12_12 bn12_12 bn13_12 0.24656
rbrv12_13 bn12_13 bn13_13 0.081712
rbrh13_0 bn13_0 bn13_1 0.11402
rbrh13_1 bn13_1 bn13_2 0.16974
rbrh13_2 bn13_2 bn13_3 76.296
rbrh13_3 bn13_3 bn13_4 86.831
rbrh13_4 bn13_4 bn13_5 23.337
rbrh13_5 bn13_5 bn13_6 45.065
rbrh13_6 bn13_6 bn13_7 0.012011
rbrh13_7 bn13_7 bn13_8 30.255
rbrh13_8 bn13_8 bn13_9 0.026531
rbrh13_9 bn13_9 bn13_10 60.089
rbrh13_10 bn13_10 bn13_11 2.717
rbrh13_11 bn13_11 bn13_12 49.3
rbrh13_12 bn13_12 bn13_13 0.042969
rbp0 bp1 bn0_0 0.01
rbp1 bn0_13 0 0.01
rbp2 bn13_0 0 0.01
rbp3 bp2 bn13_13 0.01
vb1 bp1 0 DC 0
vb2 bp2 0 DC -0.7
ib3 0 bn7_4 DC 0
rcrh0_0 cn0_0 cn0_1 0.07949
rcrv0_0 cn0_0 cn1_0 0.043191
rcrh0_1 cn0_1 cn0_2 0.028901
rcrv0_1 cn0_1 cn1_1 0.77446
rcrh0_2 cn0_2 cn0_3 2.1612
rcrv0_2 cn0_2 cn1_2 0.05834
rcrh0_3 cn0_3 cn0_4 0.16298
rcrv0_3 cn0_3 cn1_3 21.178
rcrh0_4 cn0_4 cn0_5 5.4182
rcrv0_4 cn0_4 cn1_4 2.4593
rcrh0_5 cn0_5 cn0_6 0.46846
rcrv0_5 cn0_5 cn1_5 4.968
rcrh0_6 cn0_6 cn0_7 0.02753
rcrv0_6 cn0_6 cn1_6 0.13939
rcrh0_7 cn0_7 cn0_8 6.0318
rcrv0_7 cn0_7 cn1_7 60.963
rcrh0_8 cn0_8 cn0_9 0.21165
rcrv0_8 cn0_8 cn1_8 1.6668
rcrh0_9 cn0_9 cn0_10 0.010995
rcrv0_9 cn0_9 cn1_9 0.023165
rcrh0_10 cn0_10 cn0_11 16.849
rcrv0_10 cn0_10 cn1_10 10.344
rcrh0_11 cn0_11 cn0_12 2.5996
rcrv0_11 cn0_11 cn1_11 3.9229
rcrh0_12 cn0_12 cn0_13 0.011808
rcrv0_12 cn0_12 cn1_12 0.19891
rcrv0_13 cn0_13 cn1_13 34.492
rcrh1_0 cn1_0 cn1_1 13.64
rcrv1_0 cn1_0 cn2_0 0.024922
rcrh1_1 cn1_1 cn1_2 0.13267
rcrv1_1 cn1_1 cn2_1 0.40219
rcrh1_2 cn1_2 cn1_3 1.7994
rcrv1_2 cn1_2 cn2_2 0.26296
rcrh1_3 cn1_3 cn1_4 0.38977
rcrv1_3 cn1_3 cn2_3 1.202
rcrh1_4 cn1_4 cn1_5 0.30597
rcrv1_4 cn1_4 cn2_4 0.23269
rcrh1_5 cn1_5 cn1_6 0.031318
rcrv1_5 cn1_5 cn2_5 1.0647
rcrh1_6 cn1_6 cn1_7 6.0872
rcrv1_6 cn1_6 cn2_6 0.25332
rcrh1_7 cn1_7 cn1_8 3.5917
rcrv1_7 cn1_7 cn2_7 0.85048
rcrh1_8 cn1_8 cn1_9 0.6922
rcrv1_8 cn1_8 cn2_8 45.621
rcrh1_9 cn1_9 cn1_10 0.71431
rcrv1_9 cn1_9 cn2_9 0.13417
rcrh1_10 cn1_10 cn1_11 0.013207
rcrv1_10 cn1_10 cn2_10 0.54203
rcrh1_11 cn1_11 cn1_12 5.5036
rcrv1_11 cn1_11 cn2_11 5.0865
rcrh1_12 cn1_12 cn1_13 10.943
rcrv1_12 cn1_12 cn2_12 1.2935
rcrv1_13 cn1_13 cn2_13 34.522
rcrh2_0 cn2_0 cn2_1 0.13683
rcrv2_0 cn2_0 cn3_0 0.14296
rcrh2_1 cn2_1 cn2_2 0.020727
rcrv2_1 cn2_1 cn3_1 0.29661
rcrh2_2 cn2_2 cn2_3 69.16
rcrv2_2 cn2_2 cn3_2 0.013871
rcrh2_3 cn2_3 cn2_4 0.38808
rcrv2_3 cn2_3 cn3_3 0.72185
rcrh2_4 cn2_4 cn2_5 82.573
rcrv2_4 cn2_4 cn3_4 0.016368
rcrh2_5 cn2_5 cn2_6 34.725
rcrv2_5 cn2_5 cn3_5 15.726
rcrh2_6 cn2_6 cn2_7 40.729
rcrv2_6 cn2_6 cn3_6 0.1815
rcrh2_7 cn2_7 cn2_8 0.339
rcrv2_7 cn2_7 cn3_7 80.753
rcrh2_8 cn2_8 cn2_9 0.17824
rcrv2_8 cn2_8 cn3_8 0.015231
rcrh2_9 cn2_9 cn2_10 0.26242
rcrv2_9 cn2_9 cn3_9 2.1893
rcrh2_10 cn2_10 cn2_11 0.039898
rcrv2_10 cn2_10 cn3_10 65.903
rcrh2_11 cn2_11 cn2_12 6.0463
rcrv2_11 cn2_11 cn3_11 1.712
rcrh2_12 cn2_12 cn2_13 7.8001
rcrv2_12 cn2_12 cn3_12 0.41694
rcrv2_13 cn2_13 cn3_13 1.8557
rcrh3_0 cn3_0 cn3_1 0.12409
rcrv3_0 cn3_0 cn4_0 68.908
rcrh3_1 cn3_1 cn3_2 0.40098
rcrv3_1 cn3_1 cn4_1 0.015704
rcrh3_2 cn3_2 cn3_3 2.9761
rcrv3_2 cn3_2 cn4_2 4.1782
rcrh3_3 cn3_3 cn3_4 32.687
rcrv3_3 cn3_3 cn4_3 10.885
rcrh3_4 cn3_4 cn3_5 92.17
rcrv3_4 cn3_4 cn4_4 0.5774
rcrh3_5 cn3_5 cn3_6 14.271
rcrv3_5 cn3_5 cn4_5 0.025447
rcrh3_6 cn3_6 cn3_7 0.011217
rcrv3_6 cn3_6 cn4_6 57.129
rcrh3_7 cn3_7 cn3_8 5.6204
rcrv3_7 cn3_7 cn4_7 12.873
rcrh3_8 cn3_8 cn3_9 66.15
rcrv3_8 cn3_8 cn4_8 4.167
rcrh3_9 cn3_9 cn3_10 29.546
rcrv3_9 cn3_9 cn4_9 11.991
rcrh3_10 cn3_10 cn3_11 0.84034
rcrv3_10 cn3_10 cn4_10 1.5378
rcrh3_11 cn3_11 cn3_12 0.77671
rcrv3_11 cn3_11 cn4_11 0.97199
rcrh3_12 cn3_12 cn3_13 0.031234
rcrv3_12 cn3_12 cn4_12 48.476
rcrv3_13 cn3_13 cn4_13 1.6643
rcrh4_0 cn4_0 cn4_1 7.9116
rcrv4_0 cn4_0 cn5_0 0.40806
rcrh4_1 cn4_1 cn4_2 0.04472
rcrv4_1 cn4_1 cn5_1 4.545
rcrh4_2 cn4_2 cn4_3 0.034361
rcrv4_2 cn4_2 cn5_2 36.836
rcrh4_3 cn4_3 cn4_4 26.16
rcrv4_3 cn4_3 cn5_3 0.20188
rcrh4_4 cn4_4 cn4_5 0.62895
rcrv4_4 cn4_4 cn5_4 2.3787
rcrh4_5 cn4_5 cn4_6 0.012442
rcrv4_5 cn4_5 cn5_5 0.019225
rcrh4_6 cn4_6 cn4_7 18.08
rcrv4_6 cn4_6 cn5_6 6.437
rcrh4_7 cn4_7 cn4_8 0.018971
rcrv4_7 cn4_7 cn5_7 0.24233
rcrh4_8 cn4_8 cn4_9 7.7019
rcrv4_8 cn4_8 cn5_8 0.17618
rcrh4_9 cn4_9 cn4_10 0.015317
rcrv4_9 cn4_9 cn5_9 1.8787
rcrh4_10 cn4_10 cn4_11 19.61
rcrv4_10 cn4_10 cn5_10 1.0689
rcrh4_11 cn4_11 cn4_12 0.2415
rcrv4_11 cn4_11 cn5_11 0.46929
rcrh4_12 cn4_12 cn4_13 0.89046
rcrv4_12 cn4_12 cn5_12 13.198
rcrv4_13 cn4_13 cn5_13 4.9925
rcrh5_0 cn5_0 cn5_1 23
rcrv5_0 cn5_0 cn6_0 0.25447
rcrh5_1 cn5_1 cn5_2 0.019077
rcrv5_1 cn5_1 cn6_1 0.040085
rcrh5_2 cn5_2 cn5_3 9.1707
rcrv5_2 cn5_2 cn6_2 36.957
rcrh5_3 cn5_3 cn5_4 36.669
rcrv5_3 cn5_3 cn6_3 3.7385
rcrh5_4 cn5_4 cn5_5 0.13621
rcrv5_4 cn5_4 cn6_4 0.37056
rcrh5_5 cn5_5 cn5_6 2.2891
rcrv5_5 cn5_5 cn6_5 35.826
rcrh5_6 cn5_6 cn5_7 63.361
rcrv5_6 cn5_6 cn6_6 38.612
rcrh5_7 cn5_7 cn5_8 29.633
rcrv5_7 cn5_7 cn6_7 0.67233
rcrh5_8 cn5_8 cn5_9 4.1311
rcrv5_8 cn5_8 cn6_8 1.4558
rcrh5_9 cn5_9 cn5_10 9.9609
rcrv5_9 cn5_9 cn6_9 1.6093
rcrh5_10 cn5_10 cn5_11 0.67203
rcrv5_10 cn5_10 cn6_10 6.2123
rcrh5_11 cn5_11 cn5_12 40.961
rcrv5_11 cn5_11 cn6_11 9.9189
rcrh5_12 cn5_12 cn5_13 0.022801
rcrv5_12 cn5_12 cn6_12 7.8165
rcrv5_13 cn5_13 cn6_13 0.20934
rcrh6_0 cn6_0 cn6_1 0.36185
rcrv6_0 cn6_0 cn7_0 0.030169
rcrh6_1 cn6_1 cn6_2 0.39251
rcrv6_1 cn6_1 cn7_1 0.02581
rcrh6_2 cn6_2 cn6_3 3.5432
rcrv6_2 cn6_2 cn7_2 5.7127
rcrh6_3 cn6_3 cn6_4 24.462
rcrv6_3 cn6_3 cn7_3 0.47624
rcrh6_4 cn6_4 cn6_5 1.2544
rcrv6_4 cn6_4 cn7_4 0.015166
rcrh6_5 cn6_5 cn6_6 15.202
rcrv6_5 cn6_5 cn7_5 1.0369
rcrh6_6 cn6_6 cn6_7 68.81
rcrv6_6 cn6_6 cn7_6 3.4048
rcrh6_7 cn6_7 cn6_8 15.495
rcrv6_7 cn6_7 cn7_7 0.6625
rcrh6_8 cn6_8 cn6_9 0.35928
rcrv6_8 cn6_8 cn7_8 0.20089
rcrh6_9 cn6_9 cn6_10 38.517
rcrv6_9 cn6_9 cn7_9 41.402
rcrh6_10 cn6_10 cn6_11 0.010792
rcrv6_10 cn6_10 cn7_10 3.86
rcrh6_11 cn6_11 cn6_12 0.63189
rcrv6_11 cn6_11 cn7_11 35.075
rcrh6_12 cn6_12 cn6_13 25.152
rcrv6_12 cn6_12 cn7_12 0.41562
rcrv6_13 cn6_13 cn7_13 31.334
rcrh7_0 cn7_0 cn7_1 0.075579
rcrv7_0 cn7_0 cn8_0 76
rcrh7_1 cn7_1 cn7_2 0.32575
rcrv7_1 cn7_1 cn8_1 2.6932
rcrh7_2 cn7_2 cn7_3 54.979
rcrv7_2 cn7_2 cn8_2 0.36634
rcrh7_3 cn7_3 cn7_4 55.475
rcrv7_3 cn7_3 cn8_3 5.7295
rcrh7_4 cn7_4 cn7_5 0.13068
rcrv7_4 cn7_4 cn8_4 8.8078
rcrh7_5 cn7_5 cn7_6 0.65371
rcrv7_5 cn7_5 cn8_5 0.015192
rcrh7_6 cn7_6 cn7_7 0.015676
rcrv7_6 cn7_6 cn8_6 0.013824
rcrh7_7 cn7_7 cn7_8 5.5302
rcrv7_7 cn7_7 cn8_7 0.073462
rcrh7_8 cn7_8 cn7_9 0.1036
rcrv7_8 cn7_8 cn8_8 0.45409
rcrh7_9 cn7_9 cn7_10 0.074468
rcrv7_9 cn7_9 cn8_9 0.18253
rcrh7_10 cn7_10 cn7_11 0.247
rcrv7_10 cn7_10 cn8_10 0.12481
rcrh7_11 cn7_11 cn7_12 10.966
rcrv7_11 cn7_11 cn8_11 0.072396
rcrh7_12 cn7_12 cn7_13 72.642
rcrv7_12 cn7_12 cn8_12 0.10097
rcrv7_13 cn7_13 cn8_13 5.9482
rcrh8_0 cn8_0 cn8_1 0.12867
rcrv8_0 cn8_0 cn9_0 0.27021
rcrh8_1 cn8_1 cn8_2 0.019452
rcrv8_1 cn8_1 cn9_1 0.078267
rcrh8_2 cn8_2 cn8_3 5.2072
rcrv8_2 cn8_2 cn9_2 0.010993
rcrh8_3 cn8_3 cn8_4 0.3659
rcrv8_3 cn8_3 cn9_3 1.8531
rcrh8_4 cn8_4 cn8_5 0.28307
rcrv8_4 cn8_4 cn9_4 0.012207
rcrh8_5 cn8_5 cn8_6 1.601
rcrv8_5 cn8_5 cn9_5 1.6014
rcrh8_6 cn8_6 cn8_7 0.38778
rcrv8_6 cn8_6 cn9_6 0.14101
rcrh8_7 cn8_7 cn8_8 0.025189
rcrv8_7 cn8_7 cn9_7 0.31118
rcrh8_8 cn8_8 cn8_9 0.11865
rcrv8_8 cn8_8 cn9_8 91.926
rcrh8_9 cn8_9 cn8_10 37.363
rcrv8_9 cn8_9 cn9_9 0.017907
rcrh8_10 cn8_10 cn8_11 50.476
rcrv8_10 cn8_10 cn9_10 0.048368
rcrh8_11 cn8_11 cn8_12 0.019765
rcrv8_11 cn8_11 cn9_11 0.063423
rcrh8_12 cn8_12 cn8_13 0.49729
rcrv8_12 cn8_12 cn9_12 31.728
rcrv8_13 cn8_13 cn9_13 0.36733
rcrh9_0 cn9_0 cn9_1 0.75078
rcrv9_0 cn9_0 cn10_0 5.9875
rcrh9_1 cn9_1 cn9_2 40.414
rcrv9_1 cn9_1 cn10_1 0.12894
rcrh9_2 cn9_2 cn9_3 0.011383
rcrv9_2 cn9_2 cn10_2 3.8191
rcrh9_3 cn9_3 cn9_4 0.043194
rcrv9_3 cn9_3 cn10_3 25.617
rcrh9_4 cn9_4 cn9_5 12.395
rcrv9_4 cn9_4 cn10_4 0.012598
rcrh9_5 cn9_5 cn9_6 0.44806
rcrv9_5 cn9_5 cn10_5 0.061961
rcrh9_6 cn9_6 cn9_7 68.951
rcrv9_6 cn9_6 cn10_6 85.972
rcrh9_7 cn9_7 cn9_8 2.8234
rcrv9_7 cn9_7 cn10_7 14.586
rcrh9_8 cn9_8 cn9_9 12.83
rcrv9_8 cn9_8 cn10_8 0.040898
rcrh9_9 cn9_9 cn9_10 26.512
rcrv9_9 cn9_9 cn10_9 19.629
rcrh9_10 cn9_10 cn9_11 2.5001
rcrv9_10 cn9_10 cn10_10 7.3621
rcrh9_11 cn9_11 cn9_12 0.042028
rcrv9_11 cn9_11 cn10_11 0.16336
rcrh9_12 cn9_12 cn9_13 2.3261
rcrv9_12 cn9_12 cn10_12 8.7872
rcrv9_13 cn9_13 cn10_13 1.2153
rcrh10_0 cn10_0 cn10_1 44.238
rcrv10_0 cn10_0 cn11_0 0.096877
rcrh10_1 cn10_1 cn10_2 0.32063
rcrv10_1 cn10_1 cn11_1 0.085631
rcrh10_2 cn10_2 cn10_3 3.604
rcrv10_2 cn10_2 cn11_2 0.01349
rcrh10_3 cn10_3 cn10_4 1.1105
rcrv10_3 cn10_3 cn11_3 50.037
rcrh10_4 cn10_4 cn10_5 3.4545
rcrv10_4 cn10_4 cn11_4 8.0998
rcrh10_5 cn10_5 cn10_6 0.047063
rcrv10_5 cn10_5 cn11_5 1.8334
rcrh10_6 cn10_6 cn10_7 1.4066
rcrv10_6 cn10_6 cn11_6 4.7506
rcrh10_7 cn10_7 cn10_8 22.016
rcrv10_7 cn10_7 cn11_7 2.1985
rcrh10_8 cn10_8 cn10_9 85.557
rcrv10_8 cn10_8 cn11_8 0.45874
rcrh10_9 cn10_9 cn10_10 0.018468
rcrv10_9 cn10_9 cn11_9 0.16103
rcrh10_10 cn10_10 cn10_11 1.2731
rcrv10_10 cn10_10 cn11_10 0.6574
rcrh10_11 cn10_11 cn10_12 26.855
rcrv10_11 cn10_11 cn11_11 0.121
rcrh10_12 cn10_12 cn10_13 0.19653
rcrv10_12 cn10_12 cn11_12 0.43759
rcrv10_13 cn10_13 cn11_13 0.20597
rcrh11_0 cn11_0 cn11_1 0.023812
rcrv11_0 cn11_0 cn12_0 0.10715
rcrh11_1 cn11_1 cn11_2 1.3
rcrv11_1 cn11_1 cn12_1 23.101
rcrh11_2 cn11_2 cn11_3 0.018708
rcrv11_2 cn11_2 cn12_2 0.097078
rcrh11_3 cn11_3 cn11_4 57.434
rcrv11_3 cn11_3 cn12_3 0.014227
rcrh11_4 cn11_4 cn11_5 88.777
rcrv11_4 cn11_4 cn12_4 35.224
rcrh11_5 cn11_5 cn11_6 0.097924
rcrv11_5 cn11_5 cn12_5 0.030583
rcrh11_6 cn11_6 cn11_7 0.048549
rcrv11_6 cn11_6 cn12_6 0.012701
rcrh11_7 cn11_7 cn11_8 0.012244
rcrv11_7 cn11_7 cn12_7 0.98937
rcrh11_8 cn11_8 cn11_9 0.010151
rcrv11_8 cn11_8 cn12_8 1.0946
rcrh11_9 cn11_9 cn11_10 33.567
rcrv11_9 cn11_9 cn12_9 1.1284
rcrh11_10 cn11_10 cn11_11 0.3389
rcrv11_10 cn11_10 cn12_10 18.839
rcrh11_11 cn11_11 cn11_12 0.23682
rcrv11_11 cn11_11 cn12_11 11.573
rcrh11_12 cn11_12 cn11_13 0.013642
rcrv11_12 cn11_12 cn12_12 0.019446
rcrv11_13 cn11_13 cn12_13 66.452
rcrh12_0 cn12_0 cn12_1 0.045887
rcrv12_0 cn12_0 cn13_0 9.1947
rcrh12_1 cn12_1 cn12_2 26.493
rcrv12_1 cn12_1 cn13_1 0.034554
rcrh12_2 cn12_2 cn12_3 41.919
rcrv12_2 cn12_2 cn13_2 5.2951
rcrh12_3 cn12_3 cn12_4 0.014956
rcrv12_3 cn12_3 cn13_3 0.17365
rcrh12_4 cn12_4 cn12_5 0.30346
rcrv12_4 cn12_4 cn13_4 0.049829
rcrh12_5 cn12_5 cn12_6 1.1352
rcrv12_5 cn12_5 cn13_5 55.118
rcrh12_6 cn12_6 cn12_7 0.62125
rcrv12_6 cn12_6 cn13_6 0.93914
rcrh12_7 cn12_7 cn12_8 0.28286
rcrv12_7 cn12_7 cn13_7 0.45716
rcrh12_8 cn12_8 cn12_9 0.012854
rcrv12_8 cn12_8 cn13_8 13.526
rcrh12_9 cn12_9 cn12_10 0.45196
rcrv12_9 cn12_9 cn13_9 1.6401
rcrh12_10 cn12_10 cn12_11 0.18978
rcrv12_10 cn12_10 cn13_10 28
rcrh12_11 cn12_11 cn12_12 0.019762
rcrv12_11 cn12_11 cn13_11 2.9465
rcrh12_12 cn12_12 cn12_13 0.019322
rcrv12_12 cn12_12 cn13_12 0.24656
rcrv12_13 cn12_13 cn13_13 0.081712
rcrh13_0 cn13_0 cn13_1 0.11402
rcrh13_1 cn13_1 cn13_2 0.16974
rcrh13_2 cn13_2 cn13_3 76.296
rcrh13_3 cn13_3 cn13_4 86.831
rcrh13_4 cn13_4 cn13_5 23.337
rcrh13_5 cn13_5 cn13_6 45.065
rcrh13_6 cn13_6 cn13_7 0.012011
rcrh13_7 cn13_7 cn13_8 30.255
rcrh13_8 cn13_8 cn13_9 0.026531
rcrh13_9 cn13_9 cn13_10 60.089
rcrh13_10 cn13_10 cn13_11 2.717
rcrh13_11 cn13_11 cn13_12 49.3
rcrh13_12 cn13_12 cn13_13 0.042969
rcp0 cp1 cn0_0 0.01
rcp1 cn0_13 0 0.01
rcp2 cn13_0 0 0.01
rcp3 cp2 cn13_13 0.01
vc1 cp1 0 DC 0
vc2 cp2 0 DC 0
ic3 0 cn7_4 DC 0.5
vref ref1 0 DC 1
rm3_3 r_3_3 ref1 1
gf3_3 0 r_3_3 fn3_3 0 1
ga3_3 r_3_3 0 an3_3 0 1
gb3_3 r_3_3 0 bn3_3 0 1
gc3_3 r_3_3 0 cn3_3 0 1
rm7_11 r_7_11 ref1 1
gf7_11 0 r_7_11 fn7_11 0 1
ga7_11 r_7_11 0 an7_11 0 1
gb7_11 r_7_11 0 bn7_11 0 1
gc7_11 r_7_11 0 cn7_11 0 1
rm11_7 r_11_7 ref1 1
gf11_7 0 r_11_7 fn11_7 0 1
ga11_7 r_11_7 0 an11_7 0 1
gb11_7 r_11_7 0 bn11_7 0 1
gc11_7 r_11_7 0 cn11_7 0 1
rm12_2 r_12_2 ref1 1
gf12_2 0 r_12_2 fn12_2 0 1
ga12_2 r_12_2 0 an12_2 0 1
gb12_2 r_12_2 0 bn12_2 0 1
gc12_2 r_12_2 0 cn12_2 0 1
.op
.end
