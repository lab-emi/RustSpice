Resistor ladder, 300 stages (1k series, 100k shunt): 13 decades of decay along the chain
* bench.id: acc_dc_lin_ladder_deep_300
* bench.group: accuracy
* bench.title: Resistor ladder, 300 stages (1k series, 100k shunt): 13 decades of decay along the chain
* bench.probes: v(n1), v(n100), v(n200), v(n300), i(v1)
* bench.tol.rel: 1e-9
* bench.tol.abs: 1e-26
* bench.floor: 1e-18
* bench.oracle: dc_linear
* bench.size: 301
* bench.tags: linear, op, dynamic_range, ladder, deep_network
* bench.note: v(n300) ~ 1e-13 V must be right in relative terms (tol.abs 1e-26); decay per stage 0.905
V1 n0 0 1
Rs1 n0 n1 1k
Rp1 n1 0 100k
Rs2 n1 n2 1k
Rp2 n2 0 100k
Rs3 n2 n3 1k
Rp3 n3 0 100k
Rs4 n3 n4 1k
Rp4 n4 0 100k
Rs5 n4 n5 1k
Rp5 n5 0 100k
Rs6 n5 n6 1k
Rp6 n6 0 100k
Rs7 n6 n7 1k
Rp7 n7 0 100k
Rs8 n7 n8 1k
Rp8 n8 0 100k
Rs9 n8 n9 1k
Rp9 n9 0 100k
Rs10 n9 n10 1k
Rp10 n10 0 100k
Rs11 n10 n11 1k
Rp11 n11 0 100k
Rs12 n11 n12 1k
Rp12 n12 0 100k
Rs13 n12 n13 1k
Rp13 n13 0 100k
Rs14 n13 n14 1k
Rp14 n14 0 100k
Rs15 n14 n15 1k
Rp15 n15 0 100k
Rs16 n15 n16 1k
Rp16 n16 0 100k
Rs17 n16 n17 1k
Rp17 n17 0 100k
Rs18 n17 n18 1k
Rp18 n18 0 100k
Rs19 n18 n19 1k
Rp19 n19 0 100k
Rs20 n19 n20 1k
Rp20 n20 0 100k
Rs21 n20 n21 1k
Rp21 n21 0 100k
Rs22 n21 n22 1k
Rp22 n22 0 100k
Rs23 n22 n23 1k
Rp23 n23 0 100k
Rs24 n23 n24 1k
Rp24 n24 0 100k
Rs25 n24 n25 1k
Rp25 n25 0 100k
Rs26 n25 n26 1k
Rp26 n26 0 100k
Rs27 n26 n27 1k
Rp27 n27 0 100k
Rs28 n27 n28 1k
Rp28 n28 0 100k
Rs29 n28 n29 1k
Rp29 n29 0 100k
Rs30 n29 n30 1k
Rp30 n30 0 100k
Rs31 n30 n31 1k
Rp31 n31 0 100k
Rs32 n31 n32 1k
Rp32 n32 0 100k
Rs33 n32 n33 1k
Rp33 n33 0 100k
Rs34 n33 n34 1k
Rp34 n34 0 100k
Rs35 n34 n35 1k
Rp35 n35 0 100k
Rs36 n35 n36 1k
Rp36 n36 0 100k
Rs37 n36 n37 1k
Rp37 n37 0 100k
Rs38 n37 n38 1k
Rp38 n38 0 100k
Rs39 n38 n39 1k
Rp39 n39 0 100k
Rs40 n39 n40 1k
Rp40 n40 0 100k
Rs41 n40 n41 1k
Rp41 n41 0 100k
Rs42 n41 n42 1k
Rp42 n42 0 100k
Rs43 n42 n43 1k
Rp43 n43 0 100k
Rs44 n43 n44 1k
Rp44 n44 0 100k
Rs45 n44 n45 1k
Rp45 n45 0 100k
Rs46 n45 n46 1k
Rp46 n46 0 100k
Rs47 n46 n47 1k
Rp47 n47 0 100k
Rs48 n47 n48 1k
Rp48 n48 0 100k
Rs49 n48 n49 1k
Rp49 n49 0 100k
Rs50 n49 n50 1k
Rp50 n50 0 100k
Rs51 n50 n51 1k
Rp51 n51 0 100k
Rs52 n51 n52 1k
Rp52 n52 0 100k
Rs53 n52 n53 1k
Rp53 n53 0 100k
Rs54 n53 n54 1k
Rp54 n54 0 100k
Rs55 n54 n55 1k
Rp55 n55 0 100k
Rs56 n55 n56 1k
Rp56 n56 0 100k
Rs57 n56 n57 1k
Rp57 n57 0 100k
Rs58 n57 n58 1k
Rp58 n58 0 100k
Rs59 n58 n59 1k
Rp59 n59 0 100k
Rs60 n59 n60 1k
Rp60 n60 0 100k
Rs61 n60 n61 1k
Rp61 n61 0 100k
Rs62 n61 n62 1k
Rp62 n62 0 100k
Rs63 n62 n63 1k
Rp63 n63 0 100k
Rs64 n63 n64 1k
Rp64 n64 0 100k
Rs65 n64 n65 1k
Rp65 n65 0 100k
Rs66 n65 n66 1k
Rp66 n66 0 100k
Rs67 n66 n67 1k
Rp67 n67 0 100k
Rs68 n67 n68 1k
Rp68 n68 0 100k
Rs69 n68 n69 1k
Rp69 n69 0 100k
Rs70 n69 n70 1k
Rp70 n70 0 100k
Rs71 n70 n71 1k
Rp71 n71 0 100k
Rs72 n71 n72 1k
Rp72 n72 0 100k
Rs73 n72 n73 1k
Rp73 n73 0 100k
Rs74 n73 n74 1k
Rp74 n74 0 100k
Rs75 n74 n75 1k
Rp75 n75 0 100k
Rs76 n75 n76 1k
Rp76 n76 0 100k
Rs77 n76 n77 1k
Rp77 n77 0 100k
Rs78 n77 n78 1k
Rp78 n78 0 100k
Rs79 n78 n79 1k
Rp79 n79 0 100k
Rs80 n79 n80 1k
Rp80 n80 0 100k
Rs81 n80 n81 1k
Rp81 n81 0 100k
Rs82 n81 n82 1k
Rp82 n82 0 100k
Rs83 n82 n83 1k
Rp83 n83 0 100k
Rs84 n83 n84 1k
Rp84 n84 0 100k
Rs85 n84 n85 1k
Rp85 n85 0 100k
Rs86 n85 n86 1k
Rp86 n86 0 100k
Rs87 n86 n87 1k
Rp87 n87 0 100k
Rs88 n87 n88 1k
Rp88 n88 0 100k
Rs89 n88 n89 1k
Rp89 n89 0 100k
Rs90 n89 n90 1k
Rp90 n90 0 100k
Rs91 n90 n91 1k
Rp91 n91 0 100k
Rs92 n91 n92 1k
Rp92 n92 0 100k
Rs93 n92 n93 1k
Rp93 n93 0 100k
Rs94 n93 n94 1k
Rp94 n94 0 100k
Rs95 n94 n95 1k
Rp95 n95 0 100k
Rs96 n95 n96 1k
Rp96 n96 0 100k
Rs97 n96 n97 1k
Rp97 n97 0 100k
Rs98 n97 n98 1k
Rp98 n98 0 100k
Rs99 n98 n99 1k
Rp99 n99 0 100k
Rs100 n99 n100 1k
Rp100 n100 0 100k
Rs101 n100 n101 1k
Rp101 n101 0 100k
Rs102 n101 n102 1k
Rp102 n102 0 100k
Rs103 n102 n103 1k
Rp103 n103 0 100k
Rs104 n103 n104 1k
Rp104 n104 0 100k
Rs105 n104 n105 1k
Rp105 n105 0 100k
Rs106 n105 n106 1k
Rp106 n106 0 100k
Rs107 n106 n107 1k
Rp107 n107 0 100k
Rs108 n107 n108 1k
Rp108 n108 0 100k
Rs109 n108 n109 1k
Rp109 n109 0 100k
Rs110 n109 n110 1k
Rp110 n110 0 100k
Rs111 n110 n111 1k
Rp111 n111 0 100k
Rs112 n111 n112 1k
Rp112 n112 0 100k
Rs113 n112 n113 1k
Rp113 n113 0 100k
Rs114 n113 n114 1k
Rp114 n114 0 100k
Rs115 n114 n115 1k
Rp115 n115 0 100k
Rs116 n115 n116 1k
Rp116 n116 0 100k
Rs117 n116 n117 1k
Rp117 n117 0 100k
Rs118 n117 n118 1k
Rp118 n118 0 100k
Rs119 n118 n119 1k
Rp119 n119 0 100k
Rs120 n119 n120 1k
Rp120 n120 0 100k
Rs121 n120 n121 1k
Rp121 n121 0 100k
Rs122 n121 n122 1k
Rp122 n122 0 100k
Rs123 n122 n123 1k
Rp123 n123 0 100k
Rs124 n123 n124 1k
Rp124 n124 0 100k
Rs125 n124 n125 1k
Rp125 n125 0 100k
Rs126 n125 n126 1k
Rp126 n126 0 100k
Rs127 n126 n127 1k
Rp127 n127 0 100k
Rs128 n127 n128 1k
Rp128 n128 0 100k
Rs129 n128 n129 1k
Rp129 n129 0 100k
Rs130 n129 n130 1k
Rp130 n130 0 100k
Rs131 n130 n131 1k
Rp131 n131 0 100k
Rs132 n131 n132 1k
Rp132 n132 0 100k
Rs133 n132 n133 1k
Rp133 n133 0 100k
Rs134 n133 n134 1k
Rp134 n134 0 100k
Rs135 n134 n135 1k
Rp135 n135 0 100k
Rs136 n135 n136 1k
Rp136 n136 0 100k
Rs137 n136 n137 1k
Rp137 n137 0 100k
Rs138 n137 n138 1k
Rp138 n138 0 100k
Rs139 n138 n139 1k
Rp139 n139 0 100k
Rs140 n139 n140 1k
Rp140 n140 0 100k
Rs141 n140 n141 1k
Rp141 n141 0 100k
Rs142 n141 n142 1k
Rp142 n142 0 100k
Rs143 n142 n143 1k
Rp143 n143 0 100k
Rs144 n143 n144 1k
Rp144 n144 0 100k
Rs145 n144 n145 1k
Rp145 n145 0 100k
Rs146 n145 n146 1k
Rp146 n146 0 100k
Rs147 n146 n147 1k
Rp147 n147 0 100k
Rs148 n147 n148 1k
Rp148 n148 0 100k
Rs149 n148 n149 1k
Rp149 n149 0 100k
Rs150 n149 n150 1k
Rp150 n150 0 100k
Rs151 n150 n151 1k
Rp151 n151 0 100k
Rs152 n151 n152 1k
Rp152 n152 0 100k
Rs153 n152 n153 1k
Rp153 n153 0 100k
Rs154 n153 n154 1k
Rp154 n154 0 100k
Rs155 n154 n155 1k
Rp155 n155 0 100k
Rs156 n155 n156 1k
Rp156 n156 0 100k
Rs157 n156 n157 1k
Rp157 n157 0 100k
Rs158 n157 n158 1k
Rp158 n158 0 100k
Rs159 n158 n159 1k
Rp159 n159 0 100k
Rs160 n159 n160 1k
Rp160 n160 0 100k
Rs161 n160 n161 1k
Rp161 n161 0 100k
Rs162 n161 n162 1k
Rp162 n162 0 100k
Rs163 n162 n163 1k
Rp163 n163 0 100k
Rs164 n163 n164 1k
Rp164 n164 0 100k
Rs165 n164 n165 1k
Rp165 n165 0 100k
Rs166 n165 n166 1k
Rp166 n166 0 100k
Rs167 n166 n167 1k
Rp167 n167 0 100k
Rs168 n167 n168 1k
Rp168 n168 0 100k
Rs169 n168 n169 1k
Rp169 n169 0 100k
Rs170 n169 n170 1k
Rp170 n170 0 100k
Rs171 n170 n171 1k
Rp171 n171 0 100k
Rs172 n171 n172 1k
Rp172 n172 0 100k
Rs173 n172 n173 1k
Rp173 n173 0 100k
Rs174 n173 n174 1k
Rp174 n174 0 100k
Rs175 n174 n175 1k
Rp175 n175 0 100k
Rs176 n175 n176 1k
Rp176 n176 0 100k
Rs177 n176 n177 1k
Rp177 n177 0 100k
Rs178 n177 n178 1k
Rp178 n178 0 100k
Rs179 n178 n179 1k
Rp179 n179 0 100k
Rs180 n179 n180 1k
Rp180 n180 0 100k
Rs181 n180 n181 1k
Rp181 n181 0 100k
Rs182 n181 n182 1k
Rp182 n182 0 100k
Rs183 n182 n183 1k
Rp183 n183 0 100k
Rs184 n183 n184 1k
Rp184 n184 0 100k
Rs185 n184 n185 1k
Rp185 n185 0 100k
Rs186 n185 n186 1k
Rp186 n186 0 100k
Rs187 n186 n187 1k
Rp187 n187 0 100k
Rs188 n187 n188 1k
Rp188 n188 0 100k
Rs189 n188 n189 1k
Rp189 n189 0 100k
Rs190 n189 n190 1k
Rp190 n190 0 100k
Rs191 n190 n191 1k
Rp191 n191 0 100k
Rs192 n191 n192 1k
Rp192 n192 0 100k
Rs193 n192 n193 1k
Rp193 n193 0 100k
Rs194 n193 n194 1k
Rp194 n194 0 100k
Rs195 n194 n195 1k
Rp195 n195 0 100k
Rs196 n195 n196 1k
Rp196 n196 0 100k
Rs197 n196 n197 1k
Rp197 n197 0 100k
Rs198 n197 n198 1k
Rp198 n198 0 100k
Rs199 n198 n199 1k
Rp199 n199 0 100k
Rs200 n199 n200 1k
Rp200 n200 0 100k
Rs201 n200 n201 1k
Rp201 n201 0 100k
Rs202 n201 n202 1k
Rp202 n202 0 100k
Rs203 n202 n203 1k
Rp203 n203 0 100k
Rs204 n203 n204 1k
Rp204 n204 0 100k
Rs205 n204 n205 1k
Rp205 n205 0 100k
Rs206 n205 n206 1k
Rp206 n206 0 100k
Rs207 n206 n207 1k
Rp207 n207 0 100k
Rs208 n207 n208 1k
Rp208 n208 0 100k
Rs209 n208 n209 1k
Rp209 n209 0 100k
Rs210 n209 n210 1k
Rp210 n210 0 100k
Rs211 n210 n211 1k
Rp211 n211 0 100k
Rs212 n211 n212 1k
Rp212 n212 0 100k
Rs213 n212 n213 1k
Rp213 n213 0 100k
Rs214 n213 n214 1k
Rp214 n214 0 100k
Rs215 n214 n215 1k
Rp215 n215 0 100k
Rs216 n215 n216 1k
Rp216 n216 0 100k
Rs217 n216 n217 1k
Rp217 n217 0 100k
Rs218 n217 n218 1k
Rp218 n218 0 100k
Rs219 n218 n219 1k
Rp219 n219 0 100k
Rs220 n219 n220 1k
Rp220 n220 0 100k
Rs221 n220 n221 1k
Rp221 n221 0 100k
Rs222 n221 n222 1k
Rp222 n222 0 100k
Rs223 n222 n223 1k
Rp223 n223 0 100k
Rs224 n223 n224 1k
Rp224 n224 0 100k
Rs225 n224 n225 1k
Rp225 n225 0 100k
Rs226 n225 n226 1k
Rp226 n226 0 100k
Rs227 n226 n227 1k
Rp227 n227 0 100k
Rs228 n227 n228 1k
Rp228 n228 0 100k
Rs229 n228 n229 1k
Rp229 n229 0 100k
Rs230 n229 n230 1k
Rp230 n230 0 100k
Rs231 n230 n231 1k
Rp231 n231 0 100k
Rs232 n231 n232 1k
Rp232 n232 0 100k
Rs233 n232 n233 1k
Rp233 n233 0 100k
Rs234 n233 n234 1k
Rp234 n234 0 100k
Rs235 n234 n235 1k
Rp235 n235 0 100k
Rs236 n235 n236 1k
Rp236 n236 0 100k
Rs237 n236 n237 1k
Rp237 n237 0 100k
Rs238 n237 n238 1k
Rp238 n238 0 100k
Rs239 n238 n239 1k
Rp239 n239 0 100k
Rs240 n239 n240 1k
Rp240 n240 0 100k
Rs241 n240 n241 1k
Rp241 n241 0 100k
Rs242 n241 n242 1k
Rp242 n242 0 100k
Rs243 n242 n243 1k
Rp243 n243 0 100k
Rs244 n243 n244 1k
Rp244 n244 0 100k
Rs245 n244 n245 1k
Rp245 n245 0 100k
Rs246 n245 n246 1k
Rp246 n246 0 100k
Rs247 n246 n247 1k
Rp247 n247 0 100k
Rs248 n247 n248 1k
Rp248 n248 0 100k
Rs249 n248 n249 1k
Rp249 n249 0 100k
Rs250 n249 n250 1k
Rp250 n250 0 100k
Rs251 n250 n251 1k
Rp251 n251 0 100k
Rs252 n251 n252 1k
Rp252 n252 0 100k
Rs253 n252 n253 1k
Rp253 n253 0 100k
Rs254 n253 n254 1k
Rp254 n254 0 100k
Rs255 n254 n255 1k
Rp255 n255 0 100k
Rs256 n255 n256 1k
Rp256 n256 0 100k
Rs257 n256 n257 1k
Rp257 n257 0 100k
Rs258 n257 n258 1k
Rp258 n258 0 100k
Rs259 n258 n259 1k
Rp259 n259 0 100k
Rs260 n259 n260 1k
Rp260 n260 0 100k
Rs261 n260 n261 1k
Rp261 n261 0 100k
Rs262 n261 n262 1k
Rp262 n262 0 100k
Rs263 n262 n263 1k
Rp263 n263 0 100k
Rs264 n263 n264 1k
Rp264 n264 0 100k
Rs265 n264 n265 1k
Rp265 n265 0 100k
Rs266 n265 n266 1k
Rp266 n266 0 100k
Rs267 n266 n267 1k
Rp267 n267 0 100k
Rs268 n267 n268 1k
Rp268 n268 0 100k
Rs269 n268 n269 1k
Rp269 n269 0 100k
Rs270 n269 n270 1k
Rp270 n270 0 100k
Rs271 n270 n271 1k
Rp271 n271 0 100k
Rs272 n271 n272 1k
Rp272 n272 0 100k
Rs273 n272 n273 1k
Rp273 n273 0 100k
Rs274 n273 n274 1k
Rp274 n274 0 100k
Rs275 n274 n275 1k
Rp275 n275 0 100k
Rs276 n275 n276 1k
Rp276 n276 0 100k
Rs277 n276 n277 1k
Rp277 n277 0 100k
Rs278 n277 n278 1k
Rp278 n278 0 100k
Rs279 n278 n279 1k
Rp279 n279 0 100k
Rs280 n279 n280 1k
Rp280 n280 0 100k
Rs281 n280 n281 1k
Rp281 n281 0 100k
Rs282 n281 n282 1k
Rp282 n282 0 100k
Rs283 n282 n283 1k
Rp283 n283 0 100k
Rs284 n283 n284 1k
Rp284 n284 0 100k
Rs285 n284 n285 1k
Rp285 n285 0 100k
Rs286 n285 n286 1k
Rp286 n286 0 100k
Rs287 n286 n287 1k
Rp287 n287 0 100k
Rs288 n287 n288 1k
Rp288 n288 0 100k
Rs289 n288 n289 1k
Rp289 n289 0 100k
Rs290 n289 n290 1k
Rp290 n290 0 100k
Rs291 n290 n291 1k
Rp291 n291 0 100k
Rs292 n291 n292 1k
Rp292 n292 0 100k
Rs293 n292 n293 1k
Rp293 n293 0 100k
Rs294 n293 n294 1k
Rp294 n294 0 100k
Rs295 n294 n295 1k
Rp295 n295 0 100k
Rs296 n295 n296 1k
Rp296 n296 0 100k
Rs297 n296 n297 1k
Rp297 n297 0 100k
Rs298 n297 n298 1k
Rp298 n298 0 100k
Rs299 n298 n299 1k
Rp299 n299 0 100k
Rs300 n299 n300 1k
Rp300 n300 0 100k
.op
.end
