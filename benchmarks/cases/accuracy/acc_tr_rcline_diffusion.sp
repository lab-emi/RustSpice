Distributed RC diffusion line (200 sections) step response
* bench.id: acc_tr_rcline_diffusion
* bench.group: accuracy
* bench.title: Distributed RC line, 200 sections of 5 ohm / 10 fF, 3.3 V step, tstep 10 ps (near-end nodes are 200x stiffer than the step)
* bench.probes: v(n2), v(n20), v(n100), v(n200)
* bench.tol.norm: 5e-3
* bench.ref.tmax: 0.1p
* bench.oracle: tran_lti
* bench.series.tstep: 40p 20p 10p 5p 2.5p 1p 0.5p
* bench.size: 200
* bench.tags: linear, tran, stiff, rc_line, series, flagship
* bench.est_rss_mib: 64
* bench.note: Distilled from audit b2 (2000-section line, 0.306 V error). .save keeps ngspice rawfiles to the four probes and ref.tmax is fixed at 0.1 ps so every series member shares one converged reference (40k rows) instead of 200 vectors x 160k rows. Weak members: at 1 ps RustSpice is only 12 % over tol.norm (5.6e-3 on v(n2)) and ngspice as-is is at 4.2e-3 (83 % of tol.norm) at 5 ps, but RustSpice is 9.5x (5 ps) and 8.9x (1 ps) worse than ngspice there; only the 40 ps and 20 ps members have PULSE corners off the grid (the 10 ps edge is shorter than the step).
V1 n0 0 PULSE(0 3.3 0 10p 10p 10n 20n)
R1 n0 n1 5
C1 n1 0 10f
R2 n1 n2 5
C2 n2 0 10f
R3 n2 n3 5
C3 n3 0 10f
R4 n3 n4 5
C4 n4 0 10f
R5 n4 n5 5
C5 n5 0 10f
R6 n5 n6 5
C6 n6 0 10f
R7 n6 n7 5
C7 n7 0 10f
R8 n7 n8 5
C8 n8 0 10f
R9 n8 n9 5
C9 n9 0 10f
R10 n9 n10 5
C10 n10 0 10f
R11 n10 n11 5
C11 n11 0 10f
R12 n11 n12 5
C12 n12 0 10f
R13 n12 n13 5
C13 n13 0 10f
R14 n13 n14 5
C14 n14 0 10f
R15 n14 n15 5
C15 n15 0 10f
R16 n15 n16 5
C16 n16 0 10f
R17 n16 n17 5
C17 n17 0 10f
R18 n17 n18 5
C18 n18 0 10f
R19 n18 n19 5
C19 n19 0 10f
R20 n19 n20 5
C20 n20 0 10f
R21 n20 n21 5
C21 n21 0 10f
R22 n21 n22 5
C22 n22 0 10f
R23 n22 n23 5
C23 n23 0 10f
R24 n23 n24 5
C24 n24 0 10f
R25 n24 n25 5
C25 n25 0 10f
R26 n25 n26 5
C26 n26 0 10f
R27 n26 n27 5
C27 n27 0 10f
R28 n27 n28 5
C28 n28 0 10f
R29 n28 n29 5
C29 n29 0 10f
R30 n29 n30 5
C30 n30 0 10f
R31 n30 n31 5
C31 n31 0 10f
R32 n31 n32 5
C32 n32 0 10f
R33 n32 n33 5
C33 n33 0 10f
R34 n33 n34 5
C34 n34 0 10f
R35 n34 n35 5
C35 n35 0 10f
R36 n35 n36 5
C36 n36 0 10f
R37 n36 n37 5
C37 n37 0 10f
R38 n37 n38 5
C38 n38 0 10f
R39 n38 n39 5
C39 n39 0 10f
R40 n39 n40 5
C40 n40 0 10f
R41 n40 n41 5
C41 n41 0 10f
R42 n41 n42 5
C42 n42 0 10f
R43 n42 n43 5
C43 n43 0 10f
R44 n43 n44 5
C44 n44 0 10f
R45 n44 n45 5
C45 n45 0 10f
R46 n45 n46 5
C46 n46 0 10f
R47 n46 n47 5
C47 n47 0 10f
R48 n47 n48 5
C48 n48 0 10f
R49 n48 n49 5
C49 n49 0 10f
R50 n49 n50 5
C50 n50 0 10f
R51 n50 n51 5
C51 n51 0 10f
R52 n51 n52 5
C52 n52 0 10f
R53 n52 n53 5
C53 n53 0 10f
R54 n53 n54 5
C54 n54 0 10f
R55 n54 n55 5
C55 n55 0 10f
R56 n55 n56 5
C56 n56 0 10f
R57 n56 n57 5
C57 n57 0 10f
R58 n57 n58 5
C58 n58 0 10f
R59 n58 n59 5
C59 n59 0 10f
R60 n59 n60 5
C60 n60 0 10f
R61 n60 n61 5
C61 n61 0 10f
R62 n61 n62 5
C62 n62 0 10f
R63 n62 n63 5
C63 n63 0 10f
R64 n63 n64 5
C64 n64 0 10f
R65 n64 n65 5
C65 n65 0 10f
R66 n65 n66 5
C66 n66 0 10f
R67 n66 n67 5
C67 n67 0 10f
R68 n67 n68 5
C68 n68 0 10f
R69 n68 n69 5
C69 n69 0 10f
R70 n69 n70 5
C70 n70 0 10f
R71 n70 n71 5
C71 n71 0 10f
R72 n71 n72 5
C72 n72 0 10f
R73 n72 n73 5
C73 n73 0 10f
R74 n73 n74 5
C74 n74 0 10f
R75 n74 n75 5
C75 n75 0 10f
R76 n75 n76 5
C76 n76 0 10f
R77 n76 n77 5
C77 n77 0 10f
R78 n77 n78 5
C78 n78 0 10f
R79 n78 n79 5
C79 n79 0 10f
R80 n79 n80 5
C80 n80 0 10f
R81 n80 n81 5
C81 n81 0 10f
R82 n81 n82 5
C82 n82 0 10f
R83 n82 n83 5
C83 n83 0 10f
R84 n83 n84 5
C84 n84 0 10f
R85 n84 n85 5
C85 n85 0 10f
R86 n85 n86 5
C86 n86 0 10f
R87 n86 n87 5
C87 n87 0 10f
R88 n87 n88 5
C88 n88 0 10f
R89 n88 n89 5
C89 n89 0 10f
R90 n89 n90 5
C90 n90 0 10f
R91 n90 n91 5
C91 n91 0 10f
R92 n91 n92 5
C92 n92 0 10f
R93 n92 n93 5
C93 n93 0 10f
R94 n93 n94 5
C94 n94 0 10f
R95 n94 n95 5
C95 n95 0 10f
R96 n95 n96 5
C96 n96 0 10f
R97 n96 n97 5
C97 n97 0 10f
R98 n97 n98 5
C98 n98 0 10f
R99 n98 n99 5
C99 n99 0 10f
R100 n99 n100 5
C100 n100 0 10f
R101 n100 n101 5
C101 n101 0 10f
R102 n101 n102 5
C102 n102 0 10f
R103 n102 n103 5
C103 n103 0 10f
R104 n103 n104 5
C104 n104 0 10f
R105 n104 n105 5
C105 n105 0 10f
R106 n105 n106 5
C106 n106 0 10f
R107 n106 n107 5
C107 n107 0 10f
R108 n107 n108 5
C108 n108 0 10f
R109 n108 n109 5
C109 n109 0 10f
R110 n109 n110 5
C110 n110 0 10f
R111 n110 n111 5
C111 n111 0 10f
R112 n111 n112 5
C112 n112 0 10f
R113 n112 n113 5
C113 n113 0 10f
R114 n113 n114 5
C114 n114 0 10f
R115 n114 n115 5
C115 n115 0 10f
R116 n115 n116 5
C116 n116 0 10f
R117 n116 n117 5
C117 n117 0 10f
R118 n117 n118 5
C118 n118 0 10f
R119 n118 n119 5
C119 n119 0 10f
R120 n119 n120 5
C120 n120 0 10f
R121 n120 n121 5
C121 n121 0 10f
R122 n121 n122 5
C122 n122 0 10f
R123 n122 n123 5
C123 n123 0 10f
R124 n123 n124 5
C124 n124 0 10f
R125 n124 n125 5
C125 n125 0 10f
R126 n125 n126 5
C126 n126 0 10f
R127 n126 n127 5
C127 n127 0 10f
R128 n127 n128 5
C128 n128 0 10f
R129 n128 n129 5
C129 n129 0 10f
R130 n129 n130 5
C130 n130 0 10f
R131 n130 n131 5
C131 n131 0 10f
R132 n131 n132 5
C132 n132 0 10f
R133 n132 n133 5
C133 n133 0 10f
R134 n133 n134 5
C134 n134 0 10f
R135 n134 n135 5
C135 n135 0 10f
R136 n135 n136 5
C136 n136 0 10f
R137 n136 n137 5
C137 n137 0 10f
R138 n137 n138 5
C138 n138 0 10f
R139 n138 n139 5
C139 n139 0 10f
R140 n139 n140 5
C140 n140 0 10f
R141 n140 n141 5
C141 n141 0 10f
R142 n141 n142 5
C142 n142 0 10f
R143 n142 n143 5
C143 n143 0 10f
R144 n143 n144 5
C144 n144 0 10f
R145 n144 n145 5
C145 n145 0 10f
R146 n145 n146 5
C146 n146 0 10f
R147 n146 n147 5
C147 n147 0 10f
R148 n147 n148 5
C148 n148 0 10f
R149 n148 n149 5
C149 n149 0 10f
R150 n149 n150 5
C150 n150 0 10f
R151 n150 n151 5
C151 n151 0 10f
R152 n151 n152 5
C152 n152 0 10f
R153 n152 n153 5
C153 n153 0 10f
R154 n153 n154 5
C154 n154 0 10f
R155 n154 n155 5
C155 n155 0 10f
R156 n155 n156 5
C156 n156 0 10f
R157 n156 n157 5
C157 n157 0 10f
R158 n157 n158 5
C158 n158 0 10f
R159 n158 n159 5
C159 n159 0 10f
R160 n159 n160 5
C160 n160 0 10f
R161 n160 n161 5
C161 n161 0 10f
R162 n161 n162 5
C162 n162 0 10f
R163 n162 n163 5
C163 n163 0 10f
R164 n163 n164 5
C164 n164 0 10f
R165 n164 n165 5
C165 n165 0 10f
R166 n165 n166 5
C166 n166 0 10f
R167 n166 n167 5
C167 n167 0 10f
R168 n167 n168 5
C168 n168 0 10f
R169 n168 n169 5
C169 n169 0 10f
R170 n169 n170 5
C170 n170 0 10f
R171 n170 n171 5
C171 n171 0 10f
R172 n171 n172 5
C172 n172 0 10f
R173 n172 n173 5
C173 n173 0 10f
R174 n173 n174 5
C174 n174 0 10f
R175 n174 n175 5
C175 n175 0 10f
R176 n175 n176 5
C176 n176 0 10f
R177 n176 n177 5
C177 n177 0 10f
R178 n177 n178 5
C178 n178 0 10f
R179 n178 n179 5
C179 n179 0 10f
R180 n179 n180 5
C180 n180 0 10f
R181 n180 n181 5
C181 n181 0 10f
R182 n181 n182 5
C182 n182 0 10f
R183 n182 n183 5
C183 n183 0 10f
R184 n183 n184 5
C184 n184 0 10f
R185 n184 n185 5
C185 n185 0 10f
R186 n185 n186 5
C186 n186 0 10f
R187 n186 n187 5
C187 n187 0 10f
R188 n187 n188 5
C188 n188 0 10f
R189 n188 n189 5
C189 n189 0 10f
R190 n189 n190 5
C190 n190 0 10f
R191 n190 n191 5
C191 n191 0 10f
R192 n191 n192 5
C192 n192 0 10f
R193 n192 n193 5
C193 n193 0 10f
R194 n193 n194 5
C194 n194 0 10f
R195 n194 n195 5
C195 n195 0 10f
R196 n195 n196 5
C196 n196 0 10f
R197 n196 n197 5
C197 n197 0 10f
R198 n197 n198 5
C198 n198 0 10f
R199 n198 n199 5
C199 n199 0 10f
R200 n199 n200 5
C200 n200 0 10f
.save v(n2) v(n20) v(n100) v(n200)
.tran 10p 4n
.end
