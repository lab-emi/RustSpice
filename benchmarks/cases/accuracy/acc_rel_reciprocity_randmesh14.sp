Reciprocity of a random 14x14 resistor mesh: four injection copies, six symmetry relations
* bench.id: acc_rel_reciprocity_randmesh14
* bench.group: accuracy
* bench.title: Reciprocity v_j(s_k) = v_k(s_j) of a random 14x14 mesh (R log-uniform 1e-2..1e2): 4 copies, 6 relation nodes
* bench.probes: v(r_ab), v(r_ac), v(r_ad), v(r_bc), v(r_bd), v(r_cd), v(an10_9), v(bn3_4), v(an0_5), v(cn3_4), v(an12_2), v(dn3_4), v(bn0_5), v(cn10_9), v(bn12_2), v(dn10_9), v(cn12_2), v(dn0_5)
* bench.tol.rel: 0
* bench.tol.abs: 1e-9
* bench.expect: match
* bench.oracle: dc_linear
* bench.size: 792
* bench.tags: linear, op, mesh, relation, twin_block, ill_conditioned, reference_free, reciprocity
* bench.est_rss_mib: 16
* bench.note: r_jk = 1 + 200*(v_j(s_k) - v_k(s_j)) built from non-loading VCCS cards, 1 A injected at s_k in copy k; the exact value of r is 1 (python dense oracle: |r-1| <= 3.3e-16, ngspice-tight <= 6.7e-13). tol.rel 0 / tol.abs 1e-9 makes the gate an asymmetry of <= 5e-12 V (<= 1e-10 of the smallest transfer voltage 0.052 V). RustSpice (UnrolledSymbolic) |r-1| <= 8.7e-11 (relative asymmetry <= 7.2e-12; separate single-mesh runs without the sensing network give 1.0e-12..2.7e-11), margin 11x. The 12 transfer voltages (0.052..0.447 V) are probed as well so that an all-zero solution cannot satisfy the relation. Natural card order.
rarh0_0 an0_0 an0_1 0.07949
rarv0_0 an0_0 an1_0 0.043191
rarh0_1 an0_1 an0_2 0.028901
rarv0_1 an0_1 an1_1 0.77446
rarh0_2 an0_2 an0_3 2.1612
rarv0_2 an0_2 an1_2 0.05834
rarh0_3 an0_3 an0_4 0.16298
rarv0_3 an0_3 an1_3 21.178
rarh0_4 an0_4 an0_5 5.4182
rarv0_4 an0_4 an1_4 2.4593
rarh0_5 an0_5 an0_6 0.46846
rarv0_5 an0_5 an1_5 4.968
rarh0_6 an0_6 an0_7 0.02753
rarv0_6 an0_6 an1_6 0.13939
rarh0_7 an0_7 an0_8 6.0318
rarv0_7 an0_7 an1_7 60.963
rarh0_8 an0_8 an0_9 0.21165
rarv0_8 an0_8 an1_8 1.6668
rarh0_9 an0_9 an0_10 0.010995
rarv0_9 an0_9 an1_9 0.023165
rarh0_10 an0_10 an0_11 16.849
rarv0_10 an0_10 an1_10 10.344
rarh0_11 an0_11 an0_12 2.5996
rarv0_11 an0_11 an1_11 3.9229
rarh0_12 an0_12 an0_13 0.011808
rarv0_12 an0_12 an1_12 0.19891
rarv0_13 an0_13 an1_13 34.492
rarh1_0 an1_0 an1_1 13.64
rarv1_0 an1_0 an2_0 0.024922
rarh1_1 an1_1 an1_2 0.13267
rarv1_1 an1_1 an2_1 0.40219
rarh1_2 an1_2 an1_3 1.7994
rarv1_2 an1_2 an2_2 0.26296
rarh1_3 an1_3 an1_4 0.38977
rarv1_3 an1_3 an2_3 1.202
rarh1_4 an1_4 an1_5 0.30597
rarv1_4 an1_4 an2_4 0.23269
rarh1_5 an1_5 an1_6 0.031318
rarv1_5 an1_5 an2_5 1.0647
rarh1_6 an1_6 an1_7 6.0872
rarv1_6 an1_6 an2_6 0.25332
rarh1_7 an1_7 an1_8 3.5917
rarv1_7 an1_7 an2_7 0.85048
rarh1_8 an1_8 an1_9 0.6922
rarv1_8 an1_8 an2_8 45.621
rarh1_9 an1_9 an1_10 0.71431
rarv1_9 an1_9 an2_9 0.13417
rarh1_10 an1_10 an1_11 0.013207
rarv1_10 an1_10 an2_10 0.54203
rarh1_11 an1_11 an1_12 5.5036
rarv1_11 an1_11 an2_11 5.0865
rarh1_12 an1_12 an1_13 10.943
rarv1_12 an1_12 an2_12 1.2935
rarv1_13 an1_13 an2_13 34.522
rarh2_0 an2_0 an2_1 0.13683
rarv2_0 an2_0 an3_0 0.14296
rarh2_1 an2_1 an2_2 0.020727
rarv2_1 an2_1 an3_1 0.29661
rarh2_2 an2_2 an2_3 69.16
rarv2_2 an2_2 an3_2 0.013871
rarh2_3 an2_3 an2_4 0.38808
rarv2_3 an2_3 an3_3 0.72185
rarh2_4 an2_4 an2_5 82.573
rarv2_4 an2_4 an3_4 0.016368
rarh2_5 an2_5 an2_6 34.725
rarv2_5 an2_5 an3_5 15.726
rarh2_6 an2_6 an2_7 40.729
rarv2_6 an2_6 an3_6 0.1815
rarh2_7 an2_7 an2_8 0.339
rarv2_7 an2_7 an3_7 80.753
rarh2_8 an2_8 an2_9 0.17824
rarv2_8 an2_8 an3_8 0.015231
rarh2_9 an2_9 an2_10 0.26242
rarv2_9 an2_9 an3_9 2.1893
rarh2_10 an2_10 an2_11 0.039898
rarv2_10 an2_10 an3_10 65.903
rarh2_11 an2_11 an2_12 6.0463
rarv2_11 an2_11 an3_11 1.712
rarh2_12 an2_12 an2_13 7.8001
rarv2_12 an2_12 an3_12 0.41694
rarv2_13 an2_13 an3_13 1.8557
rarh3_0 an3_0 an3_1 0.12409
rarv3_0 an3_0 an4_0 68.908
rarh3_1 an3_1 an3_2 0.40098
rarv3_1 an3_1 an4_1 0.015704
rarh3_2 an3_2 an3_3 2.9761
rarv3_2 an3_2 an4_2 4.1782
rarh3_3 an3_3 an3_4 32.687
rarv3_3 an3_3 an4_3 10.885
rarh3_4 an3_4 an3_5 92.17
rarv3_4 an3_4 an4_4 0.5774
rarh3_5 an3_5 an3_6 14.271
rarv3_5 an3_5 an4_5 0.025447
rarh3_6 an3_6 an3_7 0.011217
rarv3_6 an3_6 an4_6 57.129
rarh3_7 an3_7 an3_8 5.6204
rarv3_7 an3_7 an4_7 12.873
rarh3_8 an3_8 an3_9 66.15
rarv3_8 an3_8 an4_8 4.167
rarh3_9 an3_9 an3_10 29.546
rarv3_9 an3_9 an4_9 11.991
rarh3_10 an3_10 an3_11 0.84034
rarv3_10 an3_10 an4_10 1.5378
rarh3_11 an3_11 an3_12 0.77671
rarv3_11 an3_11 an4_11 0.97199
rarh3_12 an3_12 an3_13 0.031234
rarv3_12 an3_12 an4_12 48.476
rarv3_13 an3_13 an4_13 1.6643
rarh4_0 an4_0 an4_1 7.9116
rarv4_0 an4_0 an5_0 0.40806
rarh4_1 an4_1 an4_2 0.04472
rarv4_1 an4_1 an5_1 4.545
rarh4_2 an4_2 an4_3 0.034361
rarv4_2 an4_2 an5_2 36.836
rarh4_3 an4_3 an4_4 26.16
rarv4_3 an4_3 an5_3 0.20188
rarh4_4 an4_4 an4_5 0.62895
rarv4_4 an4_4 an5_4 2.3787
rarh4_5 an4_5 an4_6 0.012442
rarv4_5 an4_5 an5_5 0.019225
rarh4_6 an4_6 an4_7 18.08
rarv4_6 an4_6 an5_6 6.437
rarh4_7 an4_7 an4_8 0.018971
rarv4_7 an4_7 an5_7 0.24233
rarh4_8 an4_8 an4_9 7.7019
rarv4_8 an4_8 an5_8 0.17618
rarh4_9 an4_9 an4_10 0.015317
rarv4_9 an4_9 an5_9 1.8787
rarh4_10 an4_10 an4_11 19.61
rarv4_10 an4_10 an5_10 1.0689
rarh4_11 an4_11 an4_12 0.2415
rarv4_11 an4_11 an5_11 0.46929
rarh4_12 an4_12 an4_13 0.89046
rarv4_12 an4_12 an5_12 13.198
rarv4_13 an4_13 an5_13 4.9925
rarh5_0 an5_0 an5_1 23
rarv5_0 an5_0 an6_0 0.25447
rarh5_1 an5_1 an5_2 0.019077
rarv5_1 an5_1 an6_1 0.040085
rarh5_2 an5_2 an5_3 9.1707
rarv5_2 an5_2 an6_2 36.957
rarh5_3 an5_3 an5_4 36.669
rarv5_3 an5_3 an6_3 3.7385
rarh5_4 an5_4 an5_5 0.13621
rarv5_4 an5_4 an6_4 0.37056
rarh5_5 an5_5 an5_6 2.2891
rarv5_5 an5_5 an6_5 35.826
rarh5_6 an5_6 an5_7 63.361
rarv5_6 an5_6 an6_6 38.612
rarh5_7 an5_7 an5_8 29.633
rarv5_7 an5_7 an6_7 0.67233
rarh5_8 an5_8 an5_9 4.1311
rarv5_8 an5_8 an6_8 1.4558
rarh5_9 an5_9 an5_10 9.9609
rarv5_9 an5_9 an6_9 1.6093
rarh5_10 an5_10 an5_11 0.67203
rarv5_10 an5_10 an6_10 6.2123
rarh5_11 an5_11 an5_12 40.961
rarv5_11 an5_11 an6_11 9.9189
rarh5_12 an5_12 an5_13 0.022801
rarv5_12 an5_12 an6_12 7.8165
rarv5_13 an5_13 an6_13 0.20934
rarh6_0 an6_0 an6_1 0.36185
rarv6_0 an6_0 an7_0 0.030169
rarh6_1 an6_1 an6_2 0.39251
rarv6_1 an6_1 an7_1 0.02581
rarh6_2 an6_2 an6_3 3.5432
rarv6_2 an6_2 an7_2 5.7127
rarh6_3 an6_3 an6_4 24.462
rarv6_3 an6_3 an7_3 0.47624
rarh6_4 an6_4 an6_5 1.2544
rarv6_4 an6_4 an7_4 0.015166
rarh6_5 an6_5 an6_6 15.202
rarv6_5 an6_5 an7_5 1.0369
rarh6_6 an6_6 an6_7 68.81
rarv6_6 an6_6 an7_6 3.4048
rarh6_7 an6_7 an6_8 15.495
rarv6_7 an6_7 an7_7 0.6625
rarh6_8 an6_8 an6_9 0.35928
rarv6_8 an6_8 an7_8 0.20089
rarh6_9 an6_9 an6_10 38.517
rarv6_9 an6_9 an7_9 41.402
rarh6_10 an6_10 an6_11 0.010792
rarv6_10 an6_10 an7_10 3.86
rarh6_11 an6_11 an6_12 0.63189
rarv6_11 an6_11 an7_11 35.075
rarh6_12 an6_12 an6_13 25.152
rarv6_12 an6_12 an7_12 0.41562
rarv6_13 an6_13 an7_13 31.334
rarh7_0 an7_0 an7_1 0.075579
rarv7_0 an7_0 an8_0 76
rarh7_1 an7_1 an7_2 0.32575
rarv7_1 an7_1 an8_1 2.6932
rarh7_2 an7_2 an7_3 54.979
rarv7_2 an7_2 an8_2 0.36634
rarh7_3 an7_3 an7_4 55.475
rarv7_3 an7_3 an8_3 5.7295
rarh7_4 an7_4 an7_5 0.13068
rarv7_4 an7_4 an8_4 8.8078
rarh7_5 an7_5 an7_6 0.65371
rarv7_5 an7_5 an8_5 0.015192
rarh7_6 an7_6 an7_7 0.015676
rarv7_6 an7_6 an8_6 0.013824
rarh7_7 an7_7 an7_8 5.5302
rarv7_7 an7_7 an8_7 0.073462
rarh7_8 an7_8 an7_9 0.1036
rarv7_8 an7_8 an8_8 0.45409
rarh7_9 an7_9 an7_10 0.074468
rarv7_9 an7_9 an8_9 0.18253
rarh7_10 an7_10 an7_11 0.247
rarv7_10 an7_10 an8_10 0.12481
rarh7_11 an7_11 an7_12 10.966
rarv7_11 an7_11 an8_11 0.072396
rarh7_12 an7_12 an7_13 72.642
rarv7_12 an7_12 an8_12 0.10097
rarv7_13 an7_13 an8_13 5.9482
rarh8_0 an8_0 an8_1 0.12867
rarv8_0 an8_0 an9_0 0.27021
rarh8_1 an8_1 an8_2 0.019452
rarv8_1 an8_1 an9_1 0.078267
rarh8_2 an8_2 an8_3 5.2072
rarv8_2 an8_2 an9_2 0.010993
rarh8_3 an8_3 an8_4 0.3659
rarv8_3 an8_3 an9_3 1.8531
rarh8_4 an8_4 an8_5 0.28307
rarv8_4 an8_4 an9_4 0.012207
rarh8_5 an8_5 an8_6 1.601
rarv8_5 an8_5 an9_5 1.6014
rarh8_6 an8_6 an8_7 0.38778
rarv8_6 an8_6 an9_6 0.14101
rarh8_7 an8_7 an8_8 0.025189
rarv8_7 an8_7 an9_7 0.31118
rarh8_8 an8_8 an8_9 0.11865
rarv8_8 an8_8 an9_8 91.926
rarh8_9 an8_9 an8_10 37.363
rarv8_9 an8_9 an9_9 0.017907
rarh8_10 an8_10 an8_11 50.476
rarv8_10 an8_10 an9_10 0.048368
rarh8_11 an8_11 an8_12 0.019765
rarv8_11 an8_11 an9_11 0.063423
rarh8_12 an8_12 an8_13 0.49729
rarv8_12 an8_12 an9_12 31.728
rarv8_13 an8_13 an9_13 0.36733
rarh9_0 an9_0 an9_1 0.75078
rarv9_0 an9_0 an10_0 5.9875
rarh9_1 an9_1 an9_2 40.414
rarv9_1 an9_1 an10_1 0.12894
rarh9_2 an9_2 an9_3 0.011383
rarv9_2 an9_2 an10_2 3.8191
rarh9_3 an9_3 an9_4 0.043194
rarv9_3 an9_3 an10_3 25.617
rarh9_4 an9_4 an9_5 12.395
rarv9_4 an9_4 an10_4 0.012598
rarh9_5 an9_5 an9_6 0.44806
rarv9_5 an9_5 an10_5 0.061961
rarh9_6 an9_6 an9_7 68.951
rarv9_6 an9_6 an10_6 85.972
rarh9_7 an9_7 an9_8 2.8234
rarv9_7 an9_7 an10_7 14.586
rarh9_8 an9_8 an9_9 12.83
rarv9_8 an9_8 an10_8 0.040898
rarh9_9 an9_9 an9_10 26.512
rarv9_9 an9_9 an10_9 19.629
rarh9_10 an9_10 an9_11 2.5001
rarv9_10 an9_10 an10_10 7.3621
rarh9_11 an9_11 an9_12 0.042028
rarv9_11 an9_11 an10_11 0.16336
rarh9_12 an9_12 an9_13 2.3261
rarv9_12 an9_12 an10_12 8.7872
rarv9_13 an9_13 an10_13 1.2153
rarh10_0 an10_0 an10_1 44.238
rarv10_0 an10_0 an11_0 0.096877
rarh10_1 an10_1 an10_2 0.32063
rarv10_1 an10_1 an11_1 0.085631
rarh10_2 an10_2 an10_3 3.604
rarv10_2 an10_2 an11_2 0.01349
rarh10_3 an10_3 an10_4 1.1105
rarv10_3 an10_3 an11_3 50.037
rarh10_4 an10_4 an10_5 3.4545
rarv10_4 an10_4 an11_4 8.0998
rarh10_5 an10_5 an10_6 0.047063
rarv10_5 an10_5 an11_5 1.8334
rarh10_6 an10_6 an10_7 1.4066
rarv10_6 an10_6 an11_6 4.7506
rarh10_7 an10_7 an10_8 22.016
rarv10_7 an10_7 an11_7 2.1985
rarh10_8 an10_8 an10_9 85.557
rarv10_8 an10_8 an11_8 0.45874
rarh10_9 an10_9 an10_10 0.018468
rarv10_9 an10_9 an11_9 0.16103
rarh10_10 an10_10 an10_11 1.2731
rarv10_10 an10_10 an11_10 0.6574
rarh10_11 an10_11 an10_12 26.855
rarv10_11 an10_11 an11_11 0.121
rarh10_12 an10_12 an10_13 0.19653
rarv10_12 an10_12 an11_12 0.43759
rarv10_13 an10_13 an11_13 0.20597
rarh11_0 an11_0 an11_1 0.023812
rarv11_0 an11_0 an12_0 0.10715
rarh11_1 an11_1 an11_2 1.3
rarv11_1 an11_1 an12_1 23.101
rarh11_2 an11_2 an11_3 0.018708
rarv11_2 an11_2 an12_2 0.097078
rarh11_3 an11_3 an11_4 57.434
rarv11_3 an11_3 an12_3 0.014227
rarh11_4 an11_4 an11_5 88.777
rarv11_4 an11_4 an12_4 35.224
rarh11_5 an11_5 an11_6 0.097924
rarv11_5 an11_5 an12_5 0.030583
rarh11_6 an11_6 an11_7 0.048549
rarv11_6 an11_6 an12_6 0.012701
rarh11_7 an11_7 an11_8 0.012244
rarv11_7 an11_7 an12_7 0.98937
rarh11_8 an11_8 an11_9 0.010151
rarv11_8 an11_8 an12_8 1.0946
rarh11_9 an11_9 an11_10 33.567
rarv11_9 an11_9 an12_9 1.1284
rarh11_10 an11_10 an11_11 0.3389
rarv11_10 an11_10 an12_10 18.839
rarh11_11 an11_11 an11_12 0.23682
rarv11_11 an11_11 an12_11 11.573
rarh11_12 an11_12 an11_13 0.013642
rarv11_12 an11_12 an12_12 0.019446
rarv11_13 an11_13 an12_13 66.452
rarh12_0 an12_0 an12_1 0.045887
rarv12_0 an12_0 an13_0 9.1947
rarh12_1 an12_1 an12_2 26.493
rarv12_1 an12_1 an13_1 0.034554
rarh12_2 an12_2 an12_3 41.919
rarv12_2 an12_2 an13_2 5.2951
rarh12_3 an12_3 an12_4 0.014956
rarv12_3 an12_3 an13_3 0.17365
rarh12_4 an12_4 an12_5 0.30346
rarv12_4 an12_4 an13_4 0.049829
rarh12_5 an12_5 an12_6 1.1352
rarv12_5 an12_5 an13_5 55.118
rarh12_6 an12_6 an12_7 0.62125
rarv12_6 an12_6 an13_6 0.93914
rarh12_7 an12_7 an12_8 0.28286
rarv12_7 an12_7 an13_7 0.45716
rarh12_8 an12_8 an12_9 0.012854
rarv12_8 an12_8 an13_8 13.526
rarh12_9 an12_9 an12_10 0.45196
rarv12_9 an12_9 an13_9 1.6401
rarh12_10 an12_10 an12_11 0.18978
rarv12_10 an12_10 an13_10 28
rarh12_11 an12_11 an12_12 0.019762
rarv12_11 an12_11 an13_11 2.9465
rarh12_12 an12_12 an12_13 0.019322
rarv12_12 an12_12 an13_12 0.24656
rarv12_13 an12_13 an13_13 0.081712
rarh13_0 an13_0 an13_1 0.11402
rarh13_1 an13_1 an13_2 0.16974
rarh13_2 an13_2 an13_3 76.296
rarh13_3 an13_3 an13_4 86.831
rarh13_4 an13_4 an13_5 23.337
rarh13_5 an13_5 an13_6 45.065
rarh13_6 an13_6 an13_7 0.012011
rarh13_7 an13_7 an13_8 30.255
rarh13_8 an13_8 an13_9 0.026531
rarh13_9 an13_9 an13_10 60.089
rarh13_10 an13_10 an13_11 2.717
rarh13_11 an13_11 an13_12 49.3
rarh13_12 an13_12 an13_13 0.042969
rapad0 an0_0 0 0.01
rapad1 an0_13 0 0.01
rapad2 an13_0 0 0.01
rapad3 an13_13 0 0.01
ia 0 an3_4 DC 1
rbrh0_0 bn0_0 bn0_1 0.07949
rbrv0_0 bn0_0 bn1_0 0.043191
rbrh0_1 bn0_1 bn0_2 0.028901
rbrv0_1 bn0_1 bn1_1 0.77446
rbrh0_2 bn0_2 bn0_3 2.1612
rbrv0_2 bn0_2 bn1_2 0.05834
rbrh0_3 bn0_3 bn0_4 0.16298
rbrv0_3 bn0_3 bn1_3 21.178
rbrh0_4 bn0_4 bn0_5 5.4182
rbrv0_4 bn0_4 bn1_4 2.4593
rbrh0_5 bn0_5 bn0_6 0.46846
rbrv0_5 bn0_5 bn1_5 4.968
rbrh0_6 bn0_6 bn0_7 0.02753
rbrv0_6 bn0_6 bn1_6 0.13939
rbrh0_7 bn0_7 bn0_8 6.0318
rbrv0_7 bn0_7 bn1_7 60.963
rbrh0_8 bn0_8 bn0_9 0.21165
rbrv0_8 bn0_8 bn1_8 1.6668
rbrh0_9 bn0_9 bn0_10 0.010995
rbrv0_9 bn0_9 bn1_9 0.023165
rbrh0_10 bn0_10 bn0_11 16.849
rbrv0_10 bn0_10 bn1_10 10.344
rbrh0_11 bn0_11 bn0_12 2.5996
rbrv0_11 bn0_11 bn1_11 3.9229
rbrh0_12 bn0_12 bn0_13 0.011808
rbrv0_12 bn0_12 bn1_12 0.19891
rbrv0_13 bn0_13 bn1_13 34.492
rbrh1_0 bn1_0 bn1_1 13.64
rbrv1_0 bn1_0 bn2_0 0.024922
rbrh1_1 bn1_1 bn1_2 0.13267
rbrv1_1 bn1_1 bn2_1 0.40219
rbrh1_2 bn1_2 bn1_3 1.7994
rbrv1_2 bn1_2 bn2_2 0.26296
rbrh1_3 bn1_3 bn1_4 0.38977
rbrv1_3 bn1_3 bn2_3 1.202
rbrh1_4 bn1_4 bn1_5 0.30597
rbrv1_4 bn1_4 bn2_4 0.23269
rbrh1_5 bn1_5 bn1_6 0.031318
rbrv1_5 bn1_5 bn2_5 1.0647
rbrh1_6 bn1_6 bn1_7 6.0872
rbrv1_6 bn1_6 bn2_6 0.25332
rbrh1_7 bn1_7 bn1_8 3.5917
rbrv1_7 bn1_7 bn2_7 0.85048
rbrh1_8 bn1_8 bn1_9 0.6922
rbrv1_8 bn1_8 bn2_8 45.621
rbrh1_9 bn1_9 bn1_10 0.71431
rbrv1_9 bn1_9 bn2_9 0.13417
rbrh1_10 bn1_10 bn1_11 0.013207
rbrv1_10 bn1_10 bn2_10 0.54203
rbrh1_11 bn1_11 bn1_12 5.5036
rbrv1_11 bn1_11 bn2_11 5.0865
rbrh1_12 bn1_12 bn1_13 10.943
rbrv1_12 bn1_12 bn2_12 1.2935
rbrv1_13 bn1_13 bn2_13 34.522
rbrh2_0 bn2_0 bn2_1 0.13683
rbrv2_0 bn2_0 bn3_0 0.14296
rbrh2_1 bn2_1 bn2_2 0.020727
rbrv2_1 bn2_1 bn3_1 0.29661
rbrh2_2 bn2_2 bn2_3 69.16
rbrv2_2 bn2_2 bn3_2 0.013871
rbrh2_3 bn2_3 bn2_4 0.38808
rbrv2_3 bn2_3 bn3_3 0.72185
rbrh2_4 bn2_4 bn2_5 82.573
rbrv2_4 bn2_4 bn3_4 0.016368
rbrh2_5 bn2_5 bn2_6 34.725
rbrv2_5 bn2_5 bn3_5 15.726
rbrh2_6 bn2_6 bn2_7 40.729
rbrv2_6 bn2_6 bn3_6 0.1815
rbrh2_7 bn2_7 bn2_8 0.339
rbrv2_7 bn2_7 bn3_7 80.753
rbrh2_8 bn2_8 bn2_9 0.17824
rbrv2_8 bn2_8 bn3_8 0.015231
rbrh2_9 bn2_9 bn2_10 0.26242
rbrv2_9 bn2_9 bn3_9 2.1893
rbrh2_10 bn2_10 bn2_11 0.039898
rbrv2_10 bn2_10 bn3_10 65.903
rbrh2_11 bn2_11 bn2_12 6.0463
rbrv2_11 bn2_11 bn3_11 1.712
rbrh2_12 bn2_12 bn2_13 7.8001
rbrv2_12 bn2_12 bn3_12 0.41694
rbrv2_13 bn2_13 bn3_13 1.8557
rbrh3_0 bn3_0 bn3_1 0.12409
rbrv3_0 bn3_0 bn4_0 68.908
rbrh3_1 bn3_1 bn3_2 0.40098
rbrv3_1 bn3_1 bn4_1 0.015704
rbrh3_2 bn3_2 bn3_3 2.9761
rbrv3_2 bn3_2 bn4_2 4.1782
rbrh3_3 bn3_3 bn3_4 32.687
rbrv3_3 bn3_3 bn4_3 10.885
rbrh3_4 bn3_4 bn3_5 92.17
rbrv3_4 bn3_4 bn4_4 0.5774
rbrh3_5 bn3_5 bn3_6 14.271
rbrv3_5 bn3_5 bn4_5 0.025447
rbrh3_6 bn3_6 bn3_7 0.011217
rbrv3_6 bn3_6 bn4_6 57.129
rbrh3_7 bn3_7 bn3_8 5.6204
rbrv3_7 bn3_7 bn4_7 12.873
rbrh3_8 bn3_8 bn3_9 66.15
rbrv3_8 bn3_8 bn4_8 4.167
rbrh3_9 bn3_9 bn3_10 29.546
rbrv3_9 bn3_9 bn4_9 11.991
rbrh3_10 bn3_10 bn3_11 0.84034
rbrv3_10 bn3_10 bn4_10 1.5378
rbrh3_11 bn3_11 bn3_12 0.77671
rbrv3_11 bn3_11 bn4_11 0.97199
rbrh3_12 bn3_12 bn3_13 0.031234
rbrv3_12 bn3_12 bn4_12 48.476
rbrv3_13 bn3_13 bn4_13 1.6643
rbrh4_0 bn4_0 bn4_1 7.9116
rbrv4_0 bn4_0 bn5_0 0.40806
rbrh4_1 bn4_1 bn4_2 0.04472
rbrv4_1 bn4_1 bn5_1 4.545
rbrh4_2 bn4_2 bn4_3 0.034361
rbrv4_2 bn4_2 bn5_2 36.836
rbrh4_3 bn4_3 bn4_4 26.16
rbrv4_3 bn4_3 bn5_3 0.20188
rbrh4_4 bn4_4 bn4_5 0.62895
rbrv4_4 bn4_4 bn5_4 2.3787
rbrh4_5 bn4_5 bn4_6 0.012442
rbrv4_5 bn4_5 bn5_5 0.019225
rbrh4_6 bn4_6 bn4_7 18.08
rbrv4_6 bn4_6 bn5_6 6.437
rbrh4_7 bn4_7 bn4_8 0.018971
rbrv4_7 bn4_7 bn5_7 0.24233
rbrh4_8 bn4_8 bn4_9 7.7019
rbrv4_8 bn4_8 bn5_8 0.17618
rbrh4_9 bn4_9 bn4_10 0.015317
rbrv4_9 bn4_9 bn5_9 1.8787
rbrh4_10 bn4_10 bn4_11 19.61
rbrv4_10 bn4_10 bn5_10 1.0689
rbrh4_11 bn4_11 bn4_12 0.2415
rbrv4_11 bn4_11 bn5_11 0.46929
rbrh4_12 bn4_12 bn4_13 0.89046
rbrv4_12 bn4_12 bn5_12 13.198
rbrv4_13 bn4_13 bn5_13 4.9925
rbrh5_0 bn5_0 bn5_1 23
rbrv5_0 bn5_0 bn6_0 0.25447
rbrh5_1 bn5_1 bn5_2 0.019077
rbrv5_1 bn5_1 bn6_1 0.040085
rbrh5_2 bn5_2 bn5_3 9.1707
rbrv5_2 bn5_2 bn6_2 36.957
rbrh5_3 bn5_3 bn5_4 36.669
rbrv5_3 bn5_3 bn6_3 3.7385
rbrh5_4 bn5_4 bn5_5 0.13621
rbrv5_4 bn5_4 bn6_4 0.37056
rbrh5_5 bn5_5 bn5_6 2.2891
rbrv5_5 bn5_5 bn6_5 35.826
rbrh5_6 bn5_6 bn5_7 63.361
rbrv5_6 bn5_6 bn6_6 38.612
rbrh5_7 bn5_7 bn5_8 29.633
rbrv5_7 bn5_7 bn6_7 0.67233
rbrh5_8 bn5_8 bn5_9 4.1311
rbrv5_8 bn5_8 bn6_8 1.4558
rbrh5_9 bn5_9 bn5_10 9.9609
rbrv5_9 bn5_9 bn6_9 1.6093
rbrh5_10 bn5_10 bn5_11 0.67203
rbrv5_10 bn5_10 bn6_10 6.2123
rbrh5_11 bn5_11 bn5_12 40.961
rbrv5_11 bn5_11 bn6_11 9.9189
rbrh5_12 bn5_12 bn5_13 0.022801
rbrv5_12 bn5_12 bn6_12 7.8165
rbrv5_13 bn5_13 bn6_13 0.20934
rbrh6_0 bn6_0 bn6_1 0.36185
rbrv6_0 bn6_0 bn7_0 0.030169
rbrh6_1 bn6_1 bn6_2 0.39251
rbrv6_1 bn6_1 bn7_1 0.02581
rbrh6_2 bn6_2 bn6_3 3.5432
rbrv6_2 bn6_2 bn7_2 5.7127
rbrh6_3 bn6_3 bn6_4 24.462
rbrv6_3 bn6_3 bn7_3 0.47624
rbrh6_4 bn6_4 bn6_5 1.2544
rbrv6_4 bn6_4 bn7_4 0.015166
rbrh6_5 bn6_5 bn6_6 15.202
rbrv6_5 bn6_5 bn7_5 1.0369
rbrh6_6 bn6_6 bn6_7 68.81
rbrv6_6 bn6_6 bn7_6 3.4048
rbrh6_7 bn6_7 bn6_8 15.495
rbrv6_7 bn6_7 bn7_7 0.6625
rbrh6_8 bn6_8 bn6_9 0.35928
rbrv6_8 bn6_8 bn7_8 0.20089
rbrh6_9 bn6_9 bn6_10 38.517
rbrv6_9 bn6_9 bn7_9 41.402
rbrh6_10 bn6_10 bn6_11 0.010792
rbrv6_10 bn6_10 bn7_10 3.86
rbrh6_11 bn6_11 bn6_12 0.63189
rbrv6_11 bn6_11 bn7_11 35.075
rbrh6_12 bn6_12 bn6_13 25.152
rbrv6_12 bn6_12 bn7_12 0.41562
rbrv6_13 bn6_13 bn7_13 31.334
rbrh7_0 bn7_0 bn7_1 0.075579
rbrv7_0 bn7_0 bn8_0 76
rbrh7_1 bn7_1 bn7_2 0.32575
rbrv7_1 bn7_1 bn8_1 2.6932
rbrh7_2 bn7_2 bn7_3 54.979
rbrv7_2 bn7_2 bn8_2 0.36634
rbrh7_3 bn7_3 bn7_4 55.475
rbrv7_3 bn7_3 bn8_3 5.7295
rbrh7_4 bn7_4 bn7_5 0.13068
rbrv7_4 bn7_4 bn8_4 8.8078
rbrh7_5 bn7_5 bn7_6 0.65371
rbrv7_5 bn7_5 bn8_5 0.015192
rbrh7_6 bn7_6 bn7_7 0.015676
rbrv7_6 bn7_6 bn8_6 0.013824
rbrh7_7 bn7_7 bn7_8 5.5302
rbrv7_7 bn7_7 bn8_7 0.073462
rbrh7_8 bn7_8 bn7_9 0.1036
rbrv7_8 bn7_8 bn8_8 0.45409
rbrh7_9 bn7_9 bn7_10 0.074468
rbrv7_9 bn7_9 bn8_9 0.18253
rbrh7_10 bn7_10 bn7_11 0.247
rbrv7_10 bn7_10 bn8_10 0.12481
rbrh7_11 bn7_11 bn7_12 10.966
rbrv7_11 bn7_11 bn8_11 0.072396
rbrh7_12 bn7_12 bn7_13 72.642
rbrv7_12 bn7_12 bn8_12 0.10097
rbrv7_13 bn7_13 bn8_13 5.9482
rbrh8_0 bn8_0 bn8_1 0.12867
rbrv8_0 bn8_0 bn9_0 0.27021
rbrh8_1 bn8_1 bn8_2 0.019452
rbrv8_1 bn8_1 bn9_1 0.078267
rbrh8_2 bn8_2 bn8_3 5.2072
rbrv8_2 bn8_2 bn9_2 0.010993
rbrh8_3 bn8_3 bn8_4 0.3659
rbrv8_3 bn8_3 bn9_3 1.8531
rbrh8_4 bn8_4 bn8_5 0.28307
rbrv8_4 bn8_4 bn9_4 0.012207
rbrh8_5 bn8_5 bn8_6 1.601
rbrv8_5 bn8_5 bn9_5 1.6014
rbrh8_6 bn8_6 bn8_7 0.38778
rbrv8_6 bn8_6 bn9_6 0.14101
rbrh8_7 bn8_7 bn8_8 0.025189
rbrv8_7 bn8_7 bn9_7 0.31118
rbrh8_8 bn8_8 bn8_9 0.11865
rbrv8_8 bn8_8 bn9_8 91.926
rbrh8_9 bn8_9 bn8_10 37.363
rbrv8_9 bn8_9 bn9_9 0.017907
rbrh8_10 bn8_10 bn8_11 50.476
rbrv8_10 bn8_10 bn9_10 0.048368
rbrh8_11 bn8_11 bn8_12 0.019765
rbrv8_11 bn8_11 bn9_11 0.063423
rbrh8_12 bn8_12 bn8_13 0.49729
rbrv8_12 bn8_12 bn9_12 31.728
rbrv8_13 bn8_13 bn9_13 0.36733
rbrh9_0 bn9_0 bn9_1 0.75078
rbrv9_0 bn9_0 bn10_0 5.9875
rbrh9_1 bn9_1 bn9_2 40.414
rbrv9_1 bn9_1 bn10_1 0.12894
rbrh9_2 bn9_2 bn9_3 0.011383
rbrv9_2 bn9_2 bn10_2 3.8191
rbrh9_3 bn9_3 bn9_4 0.043194
rbrv9_3 bn9_3 bn10_3 25.617
rbrh9_4 bn9_4 bn9_5 12.395
rbrv9_4 bn9_4 bn10_4 0.012598
rbrh9_5 bn9_5 bn9_6 0.44806
rbrv9_5 bn9_5 bn10_5 0.061961
rbrh9_6 bn9_6 bn9_7 68.951
rbrv9_6 bn9_6 bn10_6 85.972
rbrh9_7 bn9_7 bn9_8 2.8234
rbrv9_7 bn9_7 bn10_7 14.586
rbrh9_8 bn9_8 bn9_9 12.83
rbrv9_8 bn9_8 bn10_8 0.040898
rbrh9_9 bn9_9 bn9_10 26.512
rbrv9_9 bn9_9 bn10_9 19.629
rbrh9_10 bn9_10 bn9_11 2.5001
rbrv9_10 bn9_10 bn10_10 7.3621
rbrh9_11 bn9_11 bn9_12 0.042028
rbrv9_11 bn9_11 bn10_11 0.16336
rbrh9_12 bn9_12 bn9_13 2.3261
rbrv9_12 bn9_12 bn10_12 8.7872
rbrv9_13 bn9_13 bn10_13 1.2153
rbrh10_0 bn10_0 bn10_1 44.238
rbrv10_0 bn10_0 bn11_0 0.096877
rbrh10_1 bn10_1 bn10_2 0.32063
rbrv10_1 bn10_1 bn11_1 0.085631
rbrh10_2 bn10_2 bn10_3 3.604
rbrv10_2 bn10_2 bn11_2 0.01349
rbrh10_3 bn10_3 bn10_4 1.1105
rbrv10_3 bn10_3 bn11_3 50.037
rbrh10_4 bn10_4 bn10_5 3.4545
rbrv10_4 bn10_4 bn11_4 8.0998
rbrh10_5 bn10_5 bn10_6 0.047063
rbrv10_5 bn10_5 bn11_5 1.8334
rbrh10_6 bn10_6 bn10_7 1.4066
rbrv10_6 bn10_6 bn11_6 4.7506
rbrh10_7 bn10_7 bn10_8 22.016
rbrv10_7 bn10_7 bn11_7 2.1985
rbrh10_8 bn10_8 bn10_9 85.557
rbrv10_8 bn10_8 bn11_8 0.45874
rbrh10_9 bn10_9 bn10_10 0.018468
rbrv10_9 bn10_9 bn11_9 0.16103
rbrh10_10 bn10_10 bn10_11 1.2731
rbrv10_10 bn10_10 bn11_10 0.6574
rbrh10_11 bn10_11 bn10_12 26.855
rbrv10_11 bn10_11 bn11_11 0.121
rbrh10_12 bn10_12 bn10_13 0.19653
rbrv10_12 bn10_12 bn11_12 0.43759
rbrv10_13 bn10_13 bn11_13 0.20597
rbrh11_0 bn11_0 bn11_1 0.023812
rbrv11_0 bn11_0 bn12_0 0.10715
rbrh11_1 bn11_1 bn11_2 1.3
rbrv11_1 bn11_1 bn12_1 23.101
rbrh11_2 bn11_2 bn11_3 0.018708
rbrv11_2 bn11_2 bn12_2 0.097078
rbrh11_3 bn11_3 bn11_4 57.434
rbrv11_3 bn11_3 bn12_3 0.014227
rbrh11_4 bn11_4 bn11_5 88.777
rbrv11_4 bn11_4 bn12_4 35.224
rbrh11_5 bn11_5 bn11_6 0.097924
rbrv11_5 bn11_5 bn12_5 0.030583
rbrh11_6 bn11_6 bn11_7 0.048549
rbrv11_6 bn11_6 bn12_6 0.012701
rbrh11_7 bn11_7 bn11_8 0.012244
rbrv11_7 bn11_7 bn12_7 0.98937
rbrh11_8 bn11_8 bn11_9 0.010151
rbrv11_8 bn11_8 bn12_8 1.0946
rbrh11_9 bn11_9 bn11_10 33.567
rbrv11_9 bn11_9 bn12_9 1.1284
rbrh11_10 bn11_10 bn11_11 0.3389
rbrv11_10 bn11_10 bn12_10 18.839
rbrh11_11 bn11_11 bn11_12 0.23682
rbrv11_11 bn11_11 bn12_11 11.573
rbrh11_12 bn11_12 bn11_13 0.013642
rbrv11_12 bn11_12 bn12_12 0.019446
rbrv11_13 bn11_13 bn12_13 66.452
rbrh12_0 bn12_0 bn12_1 0.045887
rbrv12_0 bn12_0 bn13_0 9.1947
rbrh12_1 bn12_1 bn12_2 26.493
rbrv12_1 bn12_1 bn13_1 0.034554
rbrh12_2 bn12_2 bn12_3 41.919
rbrv12_2 bn12_2 bn13_2 5.2951
rbrh12_3 bn12_3 bn12_4 0.014956
rbrv12_3 bn12_3 bn13_3 0.17365
rbrh12_4 bn12_4 bn12_5 0.30346
rbrv12_4 bn12_4 bn13_4 0.049829
rbrh12_5 bn12_5 bn12_6 1.1352
rbrv12_5 bn12_5 bn13_5 55.118
rbrh12_6 bn12_6 bn12_7 0.62125
rbrv12_6 bn12_6 bn13_6 0.93914
rbrh12_7 bn12_7 bn12_8 0.28286
rbrv12_7 bn12_7 bn13_7 0.45716
rbrh12_8 bn12_8 bn12_9 0.012854
rbrv12_8 bn12_8 bn13_8 13.526
rbrh12_9 bn12_9 bn12_10 0.45196
rbrv12_9 bn12_9 bn13_9 1.6401
rbrh12_10 bn12_10 bn12_11 0.18978
rbrv12_10 bn12_10 bn13_10 28
rbrh12_11 bn12_11 bn12_12 0.019762
rbrv12_11 bn12_11 bn13_11 2.9465
rbrh12_12 bn12_12 bn12_13 0.019322
rbrv12_12 bn12_12 bn13_12 0.24656
rbrv12_13 bn12_13 bn13_13 0.081712
rbrh13_0 bn13_0 bn13_1 0.11402
rbrh13_1 bn13_1 bn13_2 0.16974
rbrh13_2 bn13_2 bn13_3 76.296
rbrh13_3 bn13_3 bn13_4 86.831
rbrh13_4 bn13_4 bn13_5 23.337
rbrh13_5 bn13_5 bn13_6 45.065
rbrh13_6 bn13_6 bn13_7 0.012011
rbrh13_7 bn13_7 bn13_8 30.255
rbrh13_8 bn13_8 bn13_9 0.026531
rbrh13_9 bn13_9 bn13_10 60.089
rbrh13_10 bn13_10 bn13_11 2.717
rbrh13_11 bn13_11 bn13_12 49.3
rbrh13_12 bn13_12 bn13_13 0.042969
rbpad0 bn0_0 0 0.01
rbpad1 bn0_13 0 0.01
rbpad2 bn13_0 0 0.01
rbpad3 bn13_13 0 0.01
ib 0 bn10_9 DC 1
rcrh0_0 cn0_0 cn0_1 0.07949
rcrv0_0 cn0_0 cn1_0 0.043191
rcrh0_1 cn0_1 cn0_2 0.028901
rcrv0_1 cn0_1 cn1_1 0.77446
rcrh0_2 cn0_2 cn0_3 2.1612
rcrv0_2 cn0_2 cn1_2 0.05834
rcrh0_3 cn0_3 cn0_4 0.16298
rcrv0_3 cn0_3 cn1_3 21.178
rcrh0_4 cn0_4 cn0_5 5.4182
rcrv0_4 cn0_4 cn1_4 2.4593
rcrh0_5 cn0_5 cn0_6 0.46846
rcrv0_5 cn0_5 cn1_5 4.968
rcrh0_6 cn0_6 cn0_7 0.02753
rcrv0_6 cn0_6 cn1_6 0.13939
rcrh0_7 cn0_7 cn0_8 6.0318
rcrv0_7 cn0_7 cn1_7 60.963
rcrh0_8 cn0_8 cn0_9 0.21165
rcrv0_8 cn0_8 cn1_8 1.6668
rcrh0_9 cn0_9 cn0_10 0.010995
rcrv0_9 cn0_9 cn1_9 0.023165
rcrh0_10 cn0_10 cn0_11 16.849
rcrv0_10 cn0_10 cn1_10 10.344
rcrh0_11 cn0_11 cn0_12 2.5996
rcrv0_11 cn0_11 cn1_11 3.9229
rcrh0_12 cn0_12 cn0_13 0.011808
rcrv0_12 cn0_12 cn1_12 0.19891
rcrv0_13 cn0_13 cn1_13 34.492
rcrh1_0 cn1_0 cn1_1 13.64
rcrv1_0 cn1_0 cn2_0 0.024922
rcrh1_1 cn1_1 cn1_2 0.13267
rcrv1_1 cn1_1 cn2_1 0.40219
rcrh1_2 cn1_2 cn1_3 1.7994
rcrv1_2 cn1_2 cn2_2 0.26296
rcrh1_3 cn1_3 cn1_4 0.38977
rcrv1_3 cn1_3 cn2_3 1.202
rcrh1_4 cn1_4 cn1_5 0.30597
rcrv1_4 cn1_4 cn2_4 0.23269
rcrh1_5 cn1_5 cn1_6 0.031318
rcrv1_5 cn1_5 cn2_5 1.0647
rcrh1_6 cn1_6 cn1_7 6.0872
rcrv1_6 cn1_6 cn2_6 0.25332
rcrh1_7 cn1_7 cn1_8 3.5917
rcrv1_7 cn1_7 cn2_7 0.85048
rcrh1_8 cn1_8 cn1_9 0.6922
rcrv1_8 cn1_8 cn2_8 45.621
rcrh1_9 cn1_9 cn1_10 0.71431
rcrv1_9 cn1_9 cn2_9 0.13417
rcrh1_10 cn1_10 cn1_11 0.013207
rcrv1_10 cn1_10 cn2_10 0.54203
rcrh1_11 cn1_11 cn1_12 5.5036
rcrv1_11 cn1_11 cn2_11 5.0865
rcrh1_12 cn1_12 cn1_13 10.943
rcrv1_12 cn1_12 cn2_12 1.2935
rcrv1_13 cn1_13 cn2_13 34.522
rcrh2_0 cn2_0 cn2_1 0.13683
rcrv2_0 cn2_0 cn3_0 0.14296
rcrh2_1 cn2_1 cn2_2 0.020727
rcrv2_1 cn2_1 cn3_1 0.29661
rcrh2_2 cn2_2 cn2_3 69.16
rcrv2_2 cn2_2 cn3_2 0.013871
rcrh2_3 cn2_3 cn2_4 0.38808
rcrv2_3 cn2_3 cn3_3 0.72185
rcrh2_4 cn2_4 cn2_5 82.573
rcrv2_4 cn2_4 cn3_4 0.016368
rcrh2_5 cn2_5 cn2_6 34.725
rcrv2_5 cn2_5 cn3_5 15.726
rcrh2_6 cn2_6 cn2_7 40.729
rcrv2_6 cn2_6 cn3_6 0.1815
rcrh2_7 cn2_7 cn2_8 0.339
rcrv2_7 cn2_7 cn3_7 80.753
rcrh2_8 cn2_8 cn2_9 0.17824
rcrv2_8 cn2_8 cn3_8 0.015231
rcrh2_9 cn2_9 cn2_10 0.26242
rcrv2_9 cn2_9 cn3_9 2.1893
rcrh2_10 cn2_10 cn2_11 0.039898
rcrv2_10 cn2_10 cn3_10 65.903
rcrh2_11 cn2_11 cn2_12 6.0463
rcrv2_11 cn2_11 cn3_11 1.712
rcrh2_12 cn2_12 cn2_13 7.8001
rcrv2_12 cn2_12 cn3_12 0.41694
rcrv2_13 cn2_13 cn3_13 1.8557
rcrh3_0 cn3_0 cn3_1 0.12409
rcrv3_0 cn3_0 cn4_0 68.908
rcrh3_1 cn3_1 cn3_2 0.40098
rcrv3_1 cn3_1 cn4_1 0.015704
rcrh3_2 cn3_2 cn3_3 2.9761
rcrv3_2 cn3_2 cn4_2 4.1782
rcrh3_3 cn3_3 cn3_4 32.687
rcrv3_3 cn3_3 cn4_3 10.885
rcrh3_4 cn3_4 cn3_5 92.17
rcrv3_4 cn3_4 cn4_4 0.5774
rcrh3_5 cn3_5 cn3_6 14.271
rcrv3_5 cn3_5 cn4_5 0.025447
rcrh3_6 cn3_6 cn3_7 0.011217
rcrv3_6 cn3_6 cn4_6 57.129
rcrh3_7 cn3_7 cn3_8 5.6204
rcrv3_7 cn3_7 cn4_7 12.873
rcrh3_8 cn3_8 cn3_9 66.15
rcrv3_8 cn3_8 cn4_8 4.167
rcrh3_9 cn3_9 cn3_10 29.546
rcrv3_9 cn3_9 cn4_9 11.991
rcrh3_10 cn3_10 cn3_11 0.84034
rcrv3_10 cn3_10 cn4_10 1.5378
rcrh3_11 cn3_11 cn3_12 0.77671
rcrv3_11 cn3_11 cn4_11 0.97199
rcrh3_12 cn3_12 cn3_13 0.031234
rcrv3_12 cn3_12 cn4_12 48.476
rcrv3_13 cn3_13 cn4_13 1.6643
rcrh4_0 cn4_0 cn4_1 7.9116
rcrv4_0 cn4_0 cn5_0 0.40806
rcrh4_1 cn4_1 cn4_2 0.04472
rcrv4_1 cn4_1 cn5_1 4.545
rcrh4_2 cn4_2 cn4_3 0.034361
rcrv4_2 cn4_2 cn5_2 36.836
rcrh4_3 cn4_3 cn4_4 26.16
rcrv4_3 cn4_3 cn5_3 0.20188
rcrh4_4 cn4_4 cn4_5 0.62895
rcrv4_4 cn4_4 cn5_4 2.3787
rcrh4_5 cn4_5 cn4_6 0.012442
rcrv4_5 cn4_5 cn5_5 0.019225
rcrh4_6 cn4_6 cn4_7 18.08
rcrv4_6 cn4_6 cn5_6 6.437
rcrh4_7 cn4_7 cn4_8 0.018971
rcrv4_7 cn4_7 cn5_7 0.24233
rcrh4_8 cn4_8 cn4_9 7.7019
rcrv4_8 cn4_8 cn5_8 0.17618
rcrh4_9 cn4_9 cn4_10 0.015317
rcrv4_9 cn4_9 cn5_9 1.8787
rcrh4_10 cn4_10 cn4_11 19.61
rcrv4_10 cn4_10 cn5_10 1.0689
rcrh4_11 cn4_11 cn4_12 0.2415
rcrv4_11 cn4_11 cn5_11 0.46929
rcrh4_12 cn4_12 cn4_13 0.89046
rcrv4_12 cn4_12 cn5_12 13.198
rcrv4_13 cn4_13 cn5_13 4.9925
rcrh5_0 cn5_0 cn5_1 23
rcrv5_0 cn5_0 cn6_0 0.25447
rcrh5_1 cn5_1 cn5_2 0.019077
rcrv5_1 cn5_1 cn6_1 0.040085
rcrh5_2 cn5_2 cn5_3 9.1707
rcrv5_2 cn5_2 cn6_2 36.957
rcrh5_3 cn5_3 cn5_4 36.669
rcrv5_3 cn5_3 cn6_3 3.7385
rcrh5_4 cn5_4 cn5_5 0.13621
rcrv5_4 cn5_4 cn6_4 0.37056
rcrh5_5 cn5_5 cn5_6 2.2891
rcrv5_5 cn5_5 cn6_5 35.826
rcrh5_6 cn5_6 cn5_7 63.361
rcrv5_6 cn5_6 cn6_6 38.612
rcrh5_7 cn5_7 cn5_8 29.633
rcrv5_7 cn5_7 cn6_7 0.67233
rcrh5_8 cn5_8 cn5_9 4.1311
rcrv5_8 cn5_8 cn6_8 1.4558
rcrh5_9 cn5_9 cn5_10 9.9609
rcrv5_9 cn5_9 cn6_9 1.6093
rcrh5_10 cn5_10 cn5_11 0.67203
rcrv5_10 cn5_10 cn6_10 6.2123
rcrh5_11 cn5_11 cn5_12 40.961
rcrv5_11 cn5_11 cn6_11 9.9189
rcrh5_12 cn5_12 cn5_13 0.022801
rcrv5_12 cn5_12 cn6_12 7.8165
rcrv5_13 cn5_13 cn6_13 0.20934
rcrh6_0 cn6_0 cn6_1 0.36185
rcrv6_0 cn6_0 cn7_0 0.030169
rcrh6_1 cn6_1 cn6_2 0.39251
rcrv6_1 cn6_1 cn7_1 0.02581
rcrh6_2 cn6_2 cn6_3 3.5432
rcrv6_2 cn6_2 cn7_2 5.7127
rcrh6_3 cn6_3 cn6_4 24.462
rcrv6_3 cn6_3 cn7_3 0.47624
rcrh6_4 cn6_4 cn6_5 1.2544
rcrv6_4 cn6_4 cn7_4 0.015166
rcrh6_5 cn6_5 cn6_6 15.202
rcrv6_5 cn6_5 cn7_5 1.0369
rcrh6_6 cn6_6 cn6_7 68.81
rcrv6_6 cn6_6 cn7_6 3.4048
rcrh6_7 cn6_7 cn6_8 15.495
rcrv6_7 cn6_7 cn7_7 0.6625
rcrh6_8 cn6_8 cn6_9 0.35928
rcrv6_8 cn6_8 cn7_8 0.20089
rcrh6_9 cn6_9 cn6_10 38.517
rcrv6_9 cn6_9 cn7_9 41.402
rcrh6_10 cn6_10 cn6_11 0.010792
rcrv6_10 cn6_10 cn7_10 3.86
rcrh6_11 cn6_11 cn6_12 0.63189
rcrv6_11 cn6_11 cn7_11 35.075
rcrh6_12 cn6_12 cn6_13 25.152
rcrv6_12 cn6_12 cn7_12 0.41562
rcrv6_13 cn6_13 cn7_13 31.334
rcrh7_0 cn7_0 cn7_1 0.075579
rcrv7_0 cn7_0 cn8_0 76
rcrh7_1 cn7_1 cn7_2 0.32575
rcrv7_1 cn7_1 cn8_1 2.6932
rcrh7_2 cn7_2 cn7_3 54.979
rcrv7_2 cn7_2 cn8_2 0.36634
rcrh7_3 cn7_3 cn7_4 55.475
rcrv7_3 cn7_3 cn8_3 5.7295
rcrh7_4 cn7_4 cn7_5 0.13068
rcrv7_4 cn7_4 cn8_4 8.8078
rcrh7_5 cn7_5 cn7_6 0.65371
rcrv7_5 cn7_5 cn8_5 0.015192
rcrh7_6 cn7_6 cn7_7 0.015676
rcrv7_6 cn7_6 cn8_6 0.013824
rcrh7_7 cn7_7 cn7_8 5.5302
rcrv7_7 cn7_7 cn8_7 0.073462
rcrh7_8 cn7_8 cn7_9 0.1036
rcrv7_8 cn7_8 cn8_8 0.45409
rcrh7_9 cn7_9 cn7_10 0.074468
rcrv7_9 cn7_9 cn8_9 0.18253
rcrh7_10 cn7_10 cn7_11 0.247
rcrv7_10 cn7_10 cn8_10 0.12481
rcrh7_11 cn7_11 cn7_12 10.966
rcrv7_11 cn7_11 cn8_11 0.072396
rcrh7_12 cn7_12 cn7_13 72.642
rcrv7_12 cn7_12 cn8_12 0.10097
rcrv7_13 cn7_13 cn8_13 5.9482
rcrh8_0 cn8_0 cn8_1 0.12867
rcrv8_0 cn8_0 cn9_0 0.27021
rcrh8_1 cn8_1 cn8_2 0.019452
rcrv8_1 cn8_1 cn9_1 0.078267
rcrh8_2 cn8_2 cn8_3 5.2072
rcrv8_2 cn8_2 cn9_2 0.010993
rcrh8_3 cn8_3 cn8_4 0.3659
rcrv8_3 cn8_3 cn9_3 1.8531
rcrh8_4 cn8_4 cn8_5 0.28307
rcrv8_4 cn8_4 cn9_4 0.012207
rcrh8_5 cn8_5 cn8_6 1.601
rcrv8_5 cn8_5 cn9_5 1.6014
rcrh8_6 cn8_6 cn8_7 0.38778
rcrv8_6 cn8_6 cn9_6 0.14101
rcrh8_7 cn8_7 cn8_8 0.025189
rcrv8_7 cn8_7 cn9_7 0.31118
rcrh8_8 cn8_8 cn8_9 0.11865
rcrv8_8 cn8_8 cn9_8 91.926
rcrh8_9 cn8_9 cn8_10 37.363
rcrv8_9 cn8_9 cn9_9 0.017907
rcrh8_10 cn8_10 cn8_11 50.476
rcrv8_10 cn8_10 cn9_10 0.048368
rcrh8_11 cn8_11 cn8_12 0.019765
rcrv8_11 cn8_11 cn9_11 0.063423
rcrh8_12 cn8_12 cn8_13 0.49729
rcrv8_12 cn8_12 cn9_12 31.728
rcrv8_13 cn8_13 cn9_13 0.36733
rcrh9_0 cn9_0 cn9_1 0.75078
rcrv9_0 cn9_0 cn10_0 5.9875
rcrh9_1 cn9_1 cn9_2 40.414
rcrv9_1 cn9_1 cn10_1 0.12894
rcrh9_2 cn9_2 cn9_3 0.011383
rcrv9_2 cn9_2 cn10_2 3.8191
rcrh9_3 cn9_3 cn9_4 0.043194
rcrv9_3 cn9_3 cn10_3 25.617
rcrh9_4 cn9_4 cn9_5 12.395
rcrv9_4 cn9_4 cn10_4 0.012598
rcrh9_5 cn9_5 cn9_6 0.44806
rcrv9_5 cn9_5 cn10_5 0.061961
rcrh9_6 cn9_6 cn9_7 68.951
rcrv9_6 cn9_6 cn10_6 85.972
rcrh9_7 cn9_7 cn9_8 2.8234
rcrv9_7 cn9_7 cn10_7 14.586
rcrh9_8 cn9_8 cn9_9 12.83
rcrv9_8 cn9_8 cn10_8 0.040898
rcrh9_9 cn9_9 cn9_10 26.512
rcrv9_9 cn9_9 cn10_9 19.629
rcrh9_10 cn9_10 cn9_11 2.5001
rcrv9_10 cn9_10 cn10_10 7.3621
rcrh9_11 cn9_11 cn9_12 0.042028
rcrv9_11 cn9_11 cn10_11 0.16336
rcrh9_12 cn9_12 cn9_13 2.3261
rcrv9_12 cn9_12 cn10_12 8.7872
rcrv9_13 cn9_13 cn10_13 1.2153
rcrh10_0 cn10_0 cn10_1 44.238
rcrv10_0 cn10_0 cn11_0 0.096877
rcrh10_1 cn10_1 cn10_2 0.32063
rcrv10_1 cn10_1 cn11_1 0.085631
rcrh10_2 cn10_2 cn10_3 3.604
rcrv10_2 cn10_2 cn11_2 0.01349
rcrh10_3 cn10_3 cn10_4 1.1105
rcrv10_3 cn10_3 cn11_3 50.037
rcrh10_4 cn10_4 cn10_5 3.4545
rcrv10_4 cn10_4 cn11_4 8.0998
rcrh10_5 cn10_5 cn10_6 0.047063
rcrv10_5 cn10_5 cn11_5 1.8334
rcrh10_6 cn10_6 cn10_7 1.4066
rcrv10_6 cn10_6 cn11_6 4.7506
rcrh10_7 cn10_7 cn10_8 22.016
rcrv10_7 cn10_7 cn11_7 2.1985
rcrh10_8 cn10_8 cn10_9 85.557
rcrv10_8 cn10_8 cn11_8 0.45874
rcrh10_9 cn10_9 cn10_10 0.018468
rcrv10_9 cn10_9 cn11_9 0.16103
rcrh10_10 cn10_10 cn10_11 1.2731
rcrv10_10 cn10_10 cn11_10 0.6574
rcrh10_11 cn10_11 cn10_12 26.855
rcrv10_11 cn10_11 cn11_11 0.121
rcrh10_12 cn10_12 cn10_13 0.19653
rcrv10_12 cn10_12 cn11_12 0.43759
rcrv10_13 cn10_13 cn11_13 0.20597
rcrh11_0 cn11_0 cn11_1 0.023812
rcrv11_0 cn11_0 cn12_0 0.10715
rcrh11_1 cn11_1 cn11_2 1.3
rcrv11_1 cn11_1 cn12_1 23.101
rcrh11_2 cn11_2 cn11_3 0.018708
rcrv11_2 cn11_2 cn12_2 0.097078
rcrh11_3 cn11_3 cn11_4 57.434
rcrv11_3 cn11_3 cn12_3 0.014227
rcrh11_4 cn11_4 cn11_5 88.777
rcrv11_4 cn11_4 cn12_4 35.224
rcrh11_5 cn11_5 cn11_6 0.097924
rcrv11_5 cn11_5 cn12_5 0.030583
rcrh11_6 cn11_6 cn11_7 0.048549
rcrv11_6 cn11_6 cn12_6 0.012701
rcrh11_7 cn11_7 cn11_8 0.012244
rcrv11_7 cn11_7 cn12_7 0.98937
rcrh11_8 cn11_8 cn11_9 0.010151
rcrv11_8 cn11_8 cn12_8 1.0946
rcrh11_9 cn11_9 cn11_10 33.567
rcrv11_9 cn11_9 cn12_9 1.1284
rcrh11_10 cn11_10 cn11_11 0.3389
rcrv11_10 cn11_10 cn12_10 18.839
rcrh11_11 cn11_11 cn11_12 0.23682
rcrv11_11 cn11_11 cn12_11 11.573
rcrh11_12 cn11_12 cn11_13 0.013642
rcrv11_12 cn11_12 cn12_12 0.019446
rcrv11_13 cn11_13 cn12_13 66.452
rcrh12_0 cn12_0 cn12_1 0.045887
rcrv12_0 cn12_0 cn13_0 9.1947
rcrh12_1 cn12_1 cn12_2 26.493
rcrv12_1 cn12_1 cn13_1 0.034554
rcrh12_2 cn12_2 cn12_3 41.919
rcrv12_2 cn12_2 cn13_2 5.2951
rcrh12_3 cn12_3 cn12_4 0.014956
rcrv12_3 cn12_3 cn13_3 0.17365
rcrh12_4 cn12_4 cn12_5 0.30346
rcrv12_4 cn12_4 cn13_4 0.049829
rcrh12_5 cn12_5 cn12_6 1.1352
rcrv12_5 cn12_5 cn13_5 55.118
rcrh12_6 cn12_6 cn12_7 0.62125
rcrv12_6 cn12_6 cn13_6 0.93914
rcrh12_7 cn12_7 cn12_8 0.28286
rcrv12_7 cn12_7 cn13_7 0.45716
rcrh12_8 cn12_8 cn12_9 0.012854
rcrv12_8 cn12_8 cn13_8 13.526
rcrh12_9 cn12_9 cn12_10 0.45196
rcrv12_9 cn12_9 cn13_9 1.6401
rcrh12_10 cn12_10 cn12_11 0.18978
rcrv12_10 cn12_10 cn13_10 28
rcrh12_11 cn12_11 cn12_12 0.019762
rcrv12_11 cn12_11 cn13_11 2.9465
rcrh12_12 cn12_12 cn12_13 0.019322
rcrv12_12 cn12_12 cn13_12 0.24656
rcrv12_13 cn12_13 cn13_13 0.081712
rcrh13_0 cn13_0 cn13_1 0.11402
rcrh13_1 cn13_1 cn13_2 0.16974
rcrh13_2 cn13_2 cn13_3 76.296
rcrh13_3 cn13_3 cn13_4 86.831
rcrh13_4 cn13_4 cn13_5 23.337
rcrh13_5 cn13_5 cn13_6 45.065
rcrh13_6 cn13_6 cn13_7 0.012011
rcrh13_7 cn13_7 cn13_8 30.255
rcrh13_8 cn13_8 cn13_9 0.026531
rcrh13_9 cn13_9 cn13_10 60.089
rcrh13_10 cn13_10 cn13_11 2.717
rcrh13_11 cn13_11 cn13_12 49.3
rcrh13_12 cn13_12 cn13_13 0.042969
rcpad0 cn0_0 0 0.01
rcpad1 cn0_13 0 0.01
rcpad2 cn13_0 0 0.01
rcpad3 cn13_13 0 0.01
ic 0 cn0_5 DC 1
rdrh0_0 dn0_0 dn0_1 0.07949
rdrv0_0 dn0_0 dn1_0 0.043191
rdrh0_1 dn0_1 dn0_2 0.028901
rdrv0_1 dn0_1 dn1_1 0.77446
rdrh0_2 dn0_2 dn0_3 2.1612
rdrv0_2 dn0_2 dn1_2 0.05834
rdrh0_3 dn0_3 dn0_4 0.16298
rdrv0_3 dn0_3 dn1_3 21.178
rdrh0_4 dn0_4 dn0_5 5.4182
rdrv0_4 dn0_4 dn1_4 2.4593
rdrh0_5 dn0_5 dn0_6 0.46846
rdrv0_5 dn0_5 dn1_5 4.968
rdrh0_6 dn0_6 dn0_7 0.02753
rdrv0_6 dn0_6 dn1_6 0.13939
rdrh0_7 dn0_7 dn0_8 6.0318
rdrv0_7 dn0_7 dn1_7 60.963
rdrh0_8 dn0_8 dn0_9 0.21165
rdrv0_8 dn0_8 dn1_8 1.6668
rdrh0_9 dn0_9 dn0_10 0.010995
rdrv0_9 dn0_9 dn1_9 0.023165
rdrh0_10 dn0_10 dn0_11 16.849
rdrv0_10 dn0_10 dn1_10 10.344
rdrh0_11 dn0_11 dn0_12 2.5996
rdrv0_11 dn0_11 dn1_11 3.9229
rdrh0_12 dn0_12 dn0_13 0.011808
rdrv0_12 dn0_12 dn1_12 0.19891
rdrv0_13 dn0_13 dn1_13 34.492
rdrh1_0 dn1_0 dn1_1 13.64
rdrv1_0 dn1_0 dn2_0 0.024922
rdrh1_1 dn1_1 dn1_2 0.13267
rdrv1_1 dn1_1 dn2_1 0.40219
rdrh1_2 dn1_2 dn1_3 1.7994
rdrv1_2 dn1_2 dn2_2 0.26296
rdrh1_3 dn1_3 dn1_4 0.38977
rdrv1_3 dn1_3 dn2_3 1.202
rdrh1_4 dn1_4 dn1_5 0.30597
rdrv1_4 dn1_4 dn2_4 0.23269
rdrh1_5 dn1_5 dn1_6 0.031318
rdrv1_5 dn1_5 dn2_5 1.0647
rdrh1_6 dn1_6 dn1_7 6.0872
rdrv1_6 dn1_6 dn2_6 0.25332
rdrh1_7 dn1_7 dn1_8 3.5917
rdrv1_7 dn1_7 dn2_7 0.85048
rdrh1_8 dn1_8 dn1_9 0.6922
rdrv1_8 dn1_8 dn2_8 45.621
rdrh1_9 dn1_9 dn1_10 0.71431
rdrv1_9 dn1_9 dn2_9 0.13417
rdrh1_10 dn1_10 dn1_11 0.013207
rdrv1_10 dn1_10 dn2_10 0.54203
rdrh1_11 dn1_11 dn1_12 5.5036
rdrv1_11 dn1_11 dn2_11 5.0865
rdrh1_12 dn1_12 dn1_13 10.943
rdrv1_12 dn1_12 dn2_12 1.2935
rdrv1_13 dn1_13 dn2_13 34.522
rdrh2_0 dn2_0 dn2_1 0.13683
rdrv2_0 dn2_0 dn3_0 0.14296
rdrh2_1 dn2_1 dn2_2 0.020727
rdrv2_1 dn2_1 dn3_1 0.29661
rdrh2_2 dn2_2 dn2_3 69.16
rdrv2_2 dn2_2 dn3_2 0.013871
rdrh2_3 dn2_3 dn2_4 0.38808
rdrv2_3 dn2_3 dn3_3 0.72185
rdrh2_4 dn2_4 dn2_5 82.573
rdrv2_4 dn2_4 dn3_4 0.016368
rdrh2_5 dn2_5 dn2_6 34.725
rdrv2_5 dn2_5 dn3_5 15.726
rdrh2_6 dn2_6 dn2_7 40.729
rdrv2_6 dn2_6 dn3_6 0.1815
rdrh2_7 dn2_7 dn2_8 0.339
rdrv2_7 dn2_7 dn3_7 80.753
rdrh2_8 dn2_8 dn2_9 0.17824
rdrv2_8 dn2_8 dn3_8 0.015231
rdrh2_9 dn2_9 dn2_10 0.26242
rdrv2_9 dn2_9 dn3_9 2.1893
rdrh2_10 dn2_10 dn2_11 0.039898
rdrv2_10 dn2_10 dn3_10 65.903
rdrh2_11 dn2_11 dn2_12 6.0463
rdrv2_11 dn2_11 dn3_11 1.712
rdrh2_12 dn2_12 dn2_13 7.8001
rdrv2_12 dn2_12 dn3_12 0.41694
rdrv2_13 dn2_13 dn3_13 1.8557
rdrh3_0 dn3_0 dn3_1 0.12409
rdrv3_0 dn3_0 dn4_0 68.908
rdrh3_1 dn3_1 dn3_2 0.40098
rdrv3_1 dn3_1 dn4_1 0.015704
rdrh3_2 dn3_2 dn3_3 2.9761
rdrv3_2 dn3_2 dn4_2 4.1782
rdrh3_3 dn3_3 dn3_4 32.687
rdrv3_3 dn3_3 dn4_3 10.885
rdrh3_4 dn3_4 dn3_5 92.17
rdrv3_4 dn3_4 dn4_4 0.5774
rdrh3_5 dn3_5 dn3_6 14.271
rdrv3_5 dn3_5 dn4_5 0.025447
rdrh3_6 dn3_6 dn3_7 0.011217
rdrv3_6 dn3_6 dn4_6 57.129
rdrh3_7 dn3_7 dn3_8 5.6204
rdrv3_7 dn3_7 dn4_7 12.873
rdrh3_8 dn3_8 dn3_9 66.15
rdrv3_8 dn3_8 dn4_8 4.167
rdrh3_9 dn3_9 dn3_10 29.546
rdrv3_9 dn3_9 dn4_9 11.991
rdrh3_10 dn3_10 dn3_11 0.84034
rdrv3_10 dn3_10 dn4_10 1.5378
rdrh3_11 dn3_11 dn3_12 0.77671
rdrv3_11 dn3_11 dn4_11 0.97199
rdrh3_12 dn3_12 dn3_13 0.031234
rdrv3_12 dn3_12 dn4_12 48.476
rdrv3_13 dn3_13 dn4_13 1.6643
rdrh4_0 dn4_0 dn4_1 7.9116
rdrv4_0 dn4_0 dn5_0 0.40806
rdrh4_1 dn4_1 dn4_2 0.04472
rdrv4_1 dn4_1 dn5_1 4.545
rdrh4_2 dn4_2 dn4_3 0.034361
rdrv4_2 dn4_2 dn5_2 36.836
rdrh4_3 dn4_3 dn4_4 26.16
rdrv4_3 dn4_3 dn5_3 0.20188
rdrh4_4 dn4_4 dn4_5 0.62895
rdrv4_4 dn4_4 dn5_4 2.3787
rdrh4_5 dn4_5 dn4_6 0.012442
rdrv4_5 dn4_5 dn5_5 0.019225
rdrh4_6 dn4_6 dn4_7 18.08
rdrv4_6 dn4_6 dn5_6 6.437
rdrh4_7 dn4_7 dn4_8 0.018971
rdrv4_7 dn4_7 dn5_7 0.24233
rdrh4_8 dn4_8 dn4_9 7.7019
rdrv4_8 dn4_8 dn5_8 0.17618
rdrh4_9 dn4_9 dn4_10 0.015317
rdrv4_9 dn4_9 dn5_9 1.8787
rdrh4_10 dn4_10 dn4_11 19.61
rdrv4_10 dn4_10 dn5_10 1.0689
rdrh4_11 dn4_11 dn4_12 0.2415
rdrv4_11 dn4_11 dn5_11 0.46929
rdrh4_12 dn4_12 dn4_13 0.89046
rdrv4_12 dn4_12 dn5_12 13.198
rdrv4_13 dn4_13 dn5_13 4.9925
rdrh5_0 dn5_0 dn5_1 23
rdrv5_0 dn5_0 dn6_0 0.25447
rdrh5_1 dn5_1 dn5_2 0.019077
rdrv5_1 dn5_1 dn6_1 0.040085
rdrh5_2 dn5_2 dn5_3 9.1707
rdrv5_2 dn5_2 dn6_2 36.957
rdrh5_3 dn5_3 dn5_4 36.669
rdrv5_3 dn5_3 dn6_3 3.7385
rdrh5_4 dn5_4 dn5_5 0.13621
rdrv5_4 dn5_4 dn6_4 0.37056
rdrh5_5 dn5_5 dn5_6 2.2891
rdrv5_5 dn5_5 dn6_5 35.826
rdrh5_6 dn5_6 dn5_7 63.361
rdrv5_6 dn5_6 dn6_6 38.612
rdrh5_7 dn5_7 dn5_8 29.633
rdrv5_7 dn5_7 dn6_7 0.67233
rdrh5_8 dn5_8 dn5_9 4.1311
rdrv5_8 dn5_8 dn6_8 1.4558
rdrh5_9 dn5_9 dn5_10 9.9609
rdrv5_9 dn5_9 dn6_9 1.6093
rdrh5_10 dn5_10 dn5_11 0.67203
rdrv5_10 dn5_10 dn6_10 6.2123
rdrh5_11 dn5_11 dn5_12 40.961
rdrv5_11 dn5_11 dn6_11 9.9189
rdrh5_12 dn5_12 dn5_13 0.022801
rdrv5_12 dn5_12 dn6_12 7.8165
rdrv5_13 dn5_13 dn6_13 0.20934
rdrh6_0 dn6_0 dn6_1 0.36185
rdrv6_0 dn6_0 dn7_0 0.030169
rdrh6_1 dn6_1 dn6_2 0.39251
rdrv6_1 dn6_1 dn7_1 0.02581
rdrh6_2 dn6_2 dn6_3 3.5432
rdrv6_2 dn6_2 dn7_2 5.7127
rdrh6_3 dn6_3 dn6_4 24.462
rdrv6_3 dn6_3 dn7_3 0.47624
rdrh6_4 dn6_4 dn6_5 1.2544
rdrv6_4 dn6_4 dn7_4 0.015166
rdrh6_5 dn6_5 dn6_6 15.202
rdrv6_5 dn6_5 dn7_5 1.0369
rdrh6_6 dn6_6 dn6_7 68.81
rdrv6_6 dn6_6 dn7_6 3.4048
rdrh6_7 dn6_7 dn6_8 15.495
rdrv6_7 dn6_7 dn7_7 0.6625
rdrh6_8 dn6_8 dn6_9 0.35928
rdrv6_8 dn6_8 dn7_8 0.20089
rdrh6_9 dn6_9 dn6_10 38.517
rdrv6_9 dn6_9 dn7_9 41.402
rdrh6_10 dn6_10 dn6_11 0.010792
rdrv6_10 dn6_10 dn7_10 3.86
rdrh6_11 dn6_11 dn6_12 0.63189
rdrv6_11 dn6_11 dn7_11 35.075
rdrh6_12 dn6_12 dn6_13 25.152
rdrv6_12 dn6_12 dn7_12 0.41562
rdrv6_13 dn6_13 dn7_13 31.334
rdrh7_0 dn7_0 dn7_1 0.075579
rdrv7_0 dn7_0 dn8_0 76
rdrh7_1 dn7_1 dn7_2 0.32575
rdrv7_1 dn7_1 dn8_1 2.6932
rdrh7_2 dn7_2 dn7_3 54.979
rdrv7_2 dn7_2 dn8_2 0.36634
rdrh7_3 dn7_3 dn7_4 55.475
rdrv7_3 dn7_3 dn8_3 5.7295
rdrh7_4 dn7_4 dn7_5 0.13068
rdrv7_4 dn7_4 dn8_4 8.8078
rdrh7_5 dn7_5 dn7_6 0.65371
rdrv7_5 dn7_5 dn8_5 0.015192
rdrh7_6 dn7_6 dn7_7 0.015676
rdrv7_6 dn7_6 dn8_6 0.013824
rdrh7_7 dn7_7 dn7_8 5.5302
rdrv7_7 dn7_7 dn8_7 0.073462
rdrh7_8 dn7_8 dn7_9 0.1036
rdrv7_8 dn7_8 dn8_8 0.45409
rdrh7_9 dn7_9 dn7_10 0.074468
rdrv7_9 dn7_9 dn8_9 0.18253
rdrh7_10 dn7_10 dn7_11 0.247
rdrv7_10 dn7_10 dn8_10 0.12481
rdrh7_11 dn7_11 dn7_12 10.966
rdrv7_11 dn7_11 dn8_11 0.072396
rdrh7_12 dn7_12 dn7_13 72.642
rdrv7_12 dn7_12 dn8_12 0.10097
rdrv7_13 dn7_13 dn8_13 5.9482
rdrh8_0 dn8_0 dn8_1 0.12867
rdrv8_0 dn8_0 dn9_0 0.27021
rdrh8_1 dn8_1 dn8_2 0.019452
rdrv8_1 dn8_1 dn9_1 0.078267
rdrh8_2 dn8_2 dn8_3 5.2072
rdrv8_2 dn8_2 dn9_2 0.010993
rdrh8_3 dn8_3 dn8_4 0.3659
rdrv8_3 dn8_3 dn9_3 1.8531
rdrh8_4 dn8_4 dn8_5 0.28307
rdrv8_4 dn8_4 dn9_4 0.012207
rdrh8_5 dn8_5 dn8_6 1.601
rdrv8_5 dn8_5 dn9_5 1.6014
rdrh8_6 dn8_6 dn8_7 0.38778
rdrv8_6 dn8_6 dn9_6 0.14101
rdrh8_7 dn8_7 dn8_8 0.025189
rdrv8_7 dn8_7 dn9_7 0.31118
rdrh8_8 dn8_8 dn8_9 0.11865
rdrv8_8 dn8_8 dn9_8 91.926
rdrh8_9 dn8_9 dn8_10 37.363
rdrv8_9 dn8_9 dn9_9 0.017907
rdrh8_10 dn8_10 dn8_11 50.476
rdrv8_10 dn8_10 dn9_10 0.048368
rdrh8_11 dn8_11 dn8_12 0.019765
rdrv8_11 dn8_11 dn9_11 0.063423
rdrh8_12 dn8_12 dn8_13 0.49729
rdrv8_12 dn8_12 dn9_12 31.728
rdrv8_13 dn8_13 dn9_13 0.36733
rdrh9_0 dn9_0 dn9_1 0.75078
rdrv9_0 dn9_0 dn10_0 5.9875
rdrh9_1 dn9_1 dn9_2 40.414
rdrv9_1 dn9_1 dn10_1 0.12894
rdrh9_2 dn9_2 dn9_3 0.011383
rdrv9_2 dn9_2 dn10_2 3.8191
rdrh9_3 dn9_3 dn9_4 0.043194
rdrv9_3 dn9_3 dn10_3 25.617
rdrh9_4 dn9_4 dn9_5 12.395
rdrv9_4 dn9_4 dn10_4 0.012598
rdrh9_5 dn9_5 dn9_6 0.44806
rdrv9_5 dn9_5 dn10_5 0.061961
rdrh9_6 dn9_6 dn9_7 68.951
rdrv9_6 dn9_6 dn10_6 85.972
rdrh9_7 dn9_7 dn9_8 2.8234
rdrv9_7 dn9_7 dn10_7 14.586
rdrh9_8 dn9_8 dn9_9 12.83
rdrv9_8 dn9_8 dn10_8 0.040898
rdrh9_9 dn9_9 dn9_10 26.512
rdrv9_9 dn9_9 dn10_9 19.629
rdrh9_10 dn9_10 dn9_11 2.5001
rdrv9_10 dn9_10 dn10_10 7.3621
rdrh9_11 dn9_11 dn9_12 0.042028
rdrv9_11 dn9_11 dn10_11 0.16336
rdrh9_12 dn9_12 dn9_13 2.3261
rdrv9_12 dn9_12 dn10_12 8.7872
rdrv9_13 dn9_13 dn10_13 1.2153
rdrh10_0 dn10_0 dn10_1 44.238
rdrv10_0 dn10_0 dn11_0 0.096877
rdrh10_1 dn10_1 dn10_2 0.32063
rdrv10_1 dn10_1 dn11_1 0.085631
rdrh10_2 dn10_2 dn10_3 3.604
rdrv10_2 dn10_2 dn11_2 0.01349
rdrh10_3 dn10_3 dn10_4 1.1105
rdrv10_3 dn10_3 dn11_3 50.037
rdrh10_4 dn10_4 dn10_5 3.4545
rdrv10_4 dn10_4 dn11_4 8.0998
rdrh10_5 dn10_5 dn10_6 0.047063
rdrv10_5 dn10_5 dn11_5 1.8334
rdrh10_6 dn10_6 dn10_7 1.4066
rdrv10_6 dn10_6 dn11_6 4.7506
rdrh10_7 dn10_7 dn10_8 22.016
rdrv10_7 dn10_7 dn11_7 2.1985
rdrh10_8 dn10_8 dn10_9 85.557
rdrv10_8 dn10_8 dn11_8 0.45874
rdrh10_9 dn10_9 dn10_10 0.018468
rdrv10_9 dn10_9 dn11_9 0.16103
rdrh10_10 dn10_10 dn10_11 1.2731
rdrv10_10 dn10_10 dn11_10 0.6574
rdrh10_11 dn10_11 dn10_12 26.855
rdrv10_11 dn10_11 dn11_11 0.121
rdrh10_12 dn10_12 dn10_13 0.19653
rdrv10_12 dn10_12 dn11_12 0.43759
rdrv10_13 dn10_13 dn11_13 0.20597
rdrh11_0 dn11_0 dn11_1 0.023812
rdrv11_0 dn11_0 dn12_0 0.10715
rdrh11_1 dn11_1 dn11_2 1.3
rdrv11_1 dn11_1 dn12_1 23.101
rdrh11_2 dn11_2 dn11_3 0.018708
rdrv11_2 dn11_2 dn12_2 0.097078
rdrh11_3 dn11_3 dn11_4 57.434
rdrv11_3 dn11_3 dn12_3 0.014227
rdrh11_4 dn11_4 dn11_5 88.777
rdrv11_4 dn11_4 dn12_4 35.224
rdrh11_5 dn11_5 dn11_6 0.097924
rdrv11_5 dn11_5 dn12_5 0.030583
rdrh11_6 dn11_6 dn11_7 0.048549
rdrv11_6 dn11_6 dn12_6 0.012701
rdrh11_7 dn11_7 dn11_8 0.012244
rdrv11_7 dn11_7 dn12_7 0.98937
rdrh11_8 dn11_8 dn11_9 0.010151
rdrv11_8 dn11_8 dn12_8 1.0946
rdrh11_9 dn11_9 dn11_10 33.567
rdrv11_9 dn11_9 dn12_9 1.1284
rdrh11_10 dn11_10 dn11_11 0.3389
rdrv11_10 dn11_10 dn12_10 18.839
rdrh11_11 dn11_11 dn11_12 0.23682
rdrv11_11 dn11_11 dn12_11 11.573
rdrh11_12 dn11_12 dn11_13 0.013642
rdrv11_12 dn11_12 dn12_12 0.019446
rdrv11_13 dn11_13 dn12_13 66.452
rdrh12_0 dn12_0 dn12_1 0.045887
rdrv12_0 dn12_0 dn13_0 9.1947
rdrh12_1 dn12_1 dn12_2 26.493
rdrv12_1 dn12_1 dn13_1 0.034554
rdrh12_2 dn12_2 dn12_3 41.919
rdrv12_2 dn12_2 dn13_2 5.2951
rdrh12_3 dn12_3 dn12_4 0.014956
rdrv12_3 dn12_3 dn13_3 0.17365
rdrh12_4 dn12_4 dn12_5 0.30346
rdrv12_4 dn12_4 dn13_4 0.049829
rdrh12_5 dn12_5 dn12_6 1.1352
rdrv12_5 dn12_5 dn13_5 55.118
rdrh12_6 dn12_6 dn12_7 0.62125
rdrv12_6 dn12_6 dn13_6 0.93914
rdrh12_7 dn12_7 dn12_8 0.28286
rdrv12_7 dn12_7 dn13_7 0.45716
rdrh12_8 dn12_8 dn12_9 0.012854
rdrv12_8 dn12_8 dn13_8 13.526
rdrh12_9 dn12_9 dn12_10 0.45196
rdrv12_9 dn12_9 dn13_9 1.6401
rdrh12_10 dn12_10 dn12_11 0.18978
rdrv12_10 dn12_10 dn13_10 28
rdrh12_11 dn12_11 dn12_12 0.019762
rdrv12_11 dn12_11 dn13_11 2.9465
rdrh12_12 dn12_12 dn12_13 0.019322
rdrv12_12 dn12_12 dn13_12 0.24656
rdrv12_13 dn12_13 dn13_13 0.081712
rdrh13_0 dn13_0 dn13_1 0.11402
rdrh13_1 dn13_1 dn13_2 0.16974
rdrh13_2 dn13_2 dn13_3 76.296
rdrh13_3 dn13_3 dn13_4 86.831
rdrh13_4 dn13_4 dn13_5 23.337
rdrh13_5 dn13_5 dn13_6 45.065
rdrh13_6 dn13_6 dn13_7 0.012011
rdrh13_7 dn13_7 dn13_8 30.255
rdrh13_8 dn13_8 dn13_9 0.026531
rdrh13_9 dn13_9 dn13_10 60.089
rdrh13_10 dn13_10 dn13_11 2.717
rdrh13_11 dn13_11 dn13_12 49.3
rdrh13_12 dn13_12 dn13_13 0.042969
rdpad0 dn0_0 0 0.01
rdpad1 dn0_13 0 0.01
rdpad2 dn13_0 0 0.01
rdpad3 dn13_13 0 0.01
id 0 dn12_2 DC 1
vref ref1 0 DC 1
rmab r_ab ref1 1
gpab 0 r_ab an10_9 bn3_4 200
rmac r_ac ref1 1
gpac 0 r_ac an0_5 cn3_4 200
rmad r_ad ref1 1
gpad 0 r_ad an12_2 dn3_4 200
rmbc r_bc ref1 1
gpbc 0 r_bc bn0_5 cn10_9 200
rmbd r_bd ref1 1
gpbd 0 r_bd bn12_2 dn10_9 200
rmcd r_cd ref1 1
gpcd 0 r_cd cn12_2 dn0_5 200
.op
.end
