Resistor mesh 20x20, 1 ohm links, randomly numbered nodes (shuffled element order, seed 39)
* bench.id: acc_dc_mesh_rand_unit_m20
* bench.group: accuracy
* bench.title: Resistor mesh 20x20, 1 ohm links, randomly numbered nodes (shuffled element order, seed 39)
* bench.expect: match
* bench.oracle: dc_linear
* bench.size: 401
* bench.tags: linear, op, mesh, random_numbering, ill_conditioned
* bench.note: probes: every node voltage (default); default tolerances; same mesh as the natural-order control acc_dc_mesh_natural_unit_m20 (RustSpice 6e-11 V there), only the element order differs. The matrix is only moderately conditioned (cond2 = 6.9e4; a dense f64 LU of it agrees with ngspice to 3e-15 V), so the lost digits come from the elimination order of the static pivoting, not from conditioning; the independent check solves the deck's own MNA system densely in f64 and evaluates the KCL residual of both tools' answers (RustSpice 5.7e-6 A, ngspice 1.4e-14 A).
V1 vdd 0 DC 1.0
Rh2_14 n2_14 n2_15 1
Rh9_8 n9_8 n9_9 1
Rv12_15 n12_15 n13_15 1
Rv1_6 n1_6 n2_6 1
Rv15_19 n15_19 n16_19 1
Rh19_9 n19_9 n19_10 1
Rh19_14 n19_14 n19_15 1
Rh9_4 n9_4 n9_5 1
Rv14_3 n14_3 n15_3 1
Rv8_11 n8_11 n9_11 1
Rh4_13 n4_13 n4_14 1
Rh12_9 n12_9 n12_10 1
Rv12_7 n12_7 n13_7 1
Rv18_10 n18_10 n19_10 1
Rv13_5 n13_5 n14_5 1
Rv15_5 n15_5 n16_5 1
Rv17_18 n17_18 n18_18 1
Rh3_4 n3_4 n3_5 1
Rh5_6 n5_6 n5_7 1
Rh2_10 n2_10 n2_11 1
Rh17_7 n17_7 n17_8 1
Rh19_1 n19_1 n19_2 1
Rv1_19 n1_19 n2_19 1
Rv12_14 n12_14 n13_14 1
Rh8_11 n8_11 n8_12 1
Rv0_16 n0_16 n1_16 1
Rv6_14 n6_14 n7_14 1
Rv3_16 n3_16 n4_16 1
Rv9_4 n9_4 n10_4 1
Rh8_3 n8_3 n8_4 1
Rh6_13 n6_13 n6_14 1
Rh15_5 n15_5 n15_6 1
Rh7_16 n7_16 n7_17 1
Rv15_11 n15_11 n16_11 1
Rv7_13 n7_13 n8_13 1
Rv15_0 n15_0 n16_0 1
Rv16_2 n16_2 n17_2 1
Rv4_6 n4_6 n5_6 1
Rh2_16 n2_16 n2_17 1
Rh18_2 n18_2 n18_3 1
Rh14_2 n14_2 n14_3 1
Rv4_3 n4_3 n5_3 1
Rv1_2 n1_2 n2_2 1
Rv8_1 n8_1 n9_1 1
Rv6_4 n6_4 n7_4 1
Rv12_0 n12_0 n13_0 1
Rh12_6 n12_6 n12_7 1
Rh2_6 n2_6 n2_7 1
Rh0_5 n0_5 n0_6 1
Rh6_1 n6_1 n6_2 1
Rv18_4 n18_4 n19_4 1
Rh9_0 n9_0 n9_1 1
Rh5_0 n5_0 n5_1 1
Rv7_2 n7_2 n8_2 1
Rh5_14 n5_14 n5_15 1
Rh3_3 n3_3 n3_4 1
Rh2_5 n2_5 n2_6 1
Rv3_9 n3_9 n4_9 1
Rv14_2 n14_2 n15_2 1
Rh19_18 n19_18 n19_19 1
Rv7_12 n7_12 n8_12 1
Rv5_9 n5_9 n6_9 1
Rh18_14 n18_14 n18_15 1
Rv4_19 n4_19 n5_19 1
Rh1_3 n1_3 n1_4 1
Rh18_17 n18_17 n18_18 1
Rh11_5 n11_5 n11_6 1
Rh1_13 n1_13 n1_14 1
Rh11_11 n11_11 n11_12 1
Rh4_10 n4_10 n4_11 1
Rv5_10 n5_10 n6_10 1
Rh8_6 n8_6 n8_7 1
Rh10_1 n10_1 n10_2 1
Rh2_7 n2_7 n2_8 1
Rh3_12 n3_12 n3_13 1
Rv4_4 n4_4 n5_4 1
Rv0_15 n0_15 n1_15 1
Rv9_1 n9_1 n10_1 1
Rv1_3 n1_3 n2_3 1
Rh16_17 n16_17 n16_18 1
Rv6_12 n6_12 n7_12 1
Rv9_19 n9_19 n10_19 1
Rh0_10 n0_10 n0_11 1
Rv16_4 n16_4 n17_4 1
Rv11_9 n11_9 n12_9 1
Rh7_1 n7_1 n7_2 1
Rh1_12 n1_12 n1_13 1
Rv10_19 n10_19 n11_19 1
Rv10_12 n10_12 n11_12 1
Rh19_3 n19_3 n19_4 1
Rv17_8 n17_8 n18_8 1
Rv2_15 n2_15 n3_15 1
Rv9_0 n9_0 n10_0 1
Rh11_17 n11_17 n11_18 1
Rv11_11 n11_11 n12_11 1
Rv13_9 n13_9 n14_9 1
Rv14_14 n14_14 n15_14 1
Rv3_14 n3_14 n4_14 1
Rh0_14 n0_14 n0_15 1
Rv11_19 n11_19 n12_19 1
Rh8_10 n8_10 n8_11 1
Rh1_16 n1_16 n1_17 1
Rh17_12 n17_12 n17_13 1
Rh0_13 n0_13 n0_14 1
Rh10_8 n10_8 n10_9 1
Rh18_16 n18_16 n18_17 1
Rh11_7 n11_7 n11_8 1
Rh11_16 n11_16 n11_17 1
Rh5_9 n5_9 n5_10 1
Rv18_2 n18_2 n19_2 1
Rh1_15 n1_15 n1_16 1
Rh14_8 n14_8 n14_9 1
Rh1_11 n1_11 n1_12 1
Rh18_3 n18_3 n18_4 1
Rv11_18 n11_18 n12_18 1
Rh15_7 n15_7 n15_8 1
Rv7_16 n7_16 n8_16 1
Rh9_14 n9_14 n9_15 1
Rv13_10 n13_10 n14_10 1
Rv2_13 n2_13 n3_13 1
Rh7_13 n7_13 n7_14 1
Rh3_8 n3_8 n3_9 1
Rv1_8 n1_8 n2_8 1
Rv15_8 n15_8 n16_8 1
Rv8_10 n8_10 n9_10 1
Rh1_5 n1_5 n1_6 1
Rh3_7 n3_7 n3_8 1
Rh6_2 n6_2 n6_3 1
Rh10_16 n10_16 n10_17 1
Rv17_11 n17_11 n18_11 1
Rv15_16 n15_16 n16_16 1
Rv7_8 n7_8 n8_8 1
Rv11_8 n11_8 n12_8 1
Rv6_7 n6_7 n7_7 1
Rh19_6 n19_6 n19_7 1
Rh9_5 n9_5 n9_6 1
Rh8_12 n8_12 n8_13 1
Rv17_9 n17_9 n18_9 1
Rv2_2 n2_2 n3_2 1
Rh7_6 n7_6 n7_7 1
Rh4_1 n4_1 n4_2 1
Rh5_1 n5_1 n5_2 1
Rh2_13 n2_13 n2_14 1
Rv17_10 n17_10 n18_10 1
Rv16_0 n16_0 n17_0 1
Rh15_6 n15_6 n15_7 1
Rv0_13 n0_13 n1_13 1
Rh9_15 n9_15 n9_16 1
Rh8_5 n8_5 n8_6 1
Rv6_3 n6_3 n7_3 1
Rh1_18 n1_18 n1_19 1
Rh12_8 n12_8 n12_9 1
Rh12_15 n12_15 n12_16 1
Rh15_13 n15_13 n15_14 1
Rv3_1 n3_1 n4_1 1
Rh18_18 n18_18 n18_19 1
I1 n3_10 0 DC 1m
Rh1_17 n1_17 n1_18 1
Rv2_7 n2_7 n3_7 1
Rh9_2 n9_2 n9_3 1
Rv3_3 n3_3 n4_3 1
Rv14_10 n14_10 n15_10 1
Rv4_9 n4_9 n5_9 1
Rv14_15 n14_15 n15_15 1
Rv14_4 n14_4 n15_4 1
Rv4_12 n4_12 n5_12 1
Rh17_15 n17_15 n17_16 1
Rv11_2 n11_2 n12_2 1
Rh0_4 n0_4 n0_5 1
Rh12_7 n12_7 n12_8 1
Rh8_7 n8_7 n8_8 1
Rv5_13 n5_13 n6_13 1
Rv10_3 n10_3 n11_3 1
Rh7_14 n7_14 n7_15 1
I7 n16_10 0 DC 1m
Rv6_6 n6_6 n7_6 1
Rh14_0 n14_0 n14_1 1
Rv18_16 n18_16 n19_16 1
Rh14_18 n14_18 n14_19 1
Rh15_14 n15_14 n15_15 1
Rv11_3 n11_3 n12_3 1
Rv11_4 n11_4 n12_4 1
Rv0_6 n0_6 n1_6 1
Rh17_6 n17_6 n17_7 1
Rh0_3 n0_3 n0_4 1
Rh13_0 n13_0 n13_1 1
Rv6_19 n6_19 n7_19 1
Rh15_15 n15_15 n15_16 1
Rpad0 vdd n0_0 0.01
Rv7_15 n7_15 n8_15 1
Rh9_3 n9_3 n9_4 1
Rh10_9 n10_9 n10_10 1
Rv12_12 n12_12 n13_12 1
Rh7_17 n7_17 n7_18 1
Rh1_9 n1_9 n1_10 1
Rh12_5 n12_5 n12_6 1
Rh7_10 n7_10 n7_11 1
Rv16_12 n16_12 n17_12 1
Rh11_10 n11_10 n11_11 1
Rv6_5 n6_5 n7_5 1
Rv11_14 n11_14 n12_14 1
Rv1_12 n1_12 n2_12 1
Rh9_9 n9_9 n9_10 1
Rv8_17 n8_17 n9_17 1
Rv13_7 n13_7 n14_7 1
Rv16_5 n16_5 n17_5 1
Rv4_7 n4_7 n5_7 1
Rv7_6 n7_6 n8_6 1
Rh16_11 n16_11 n16_12 1
Rv6_15 n6_15 n7_15 1
Rv4_18 n4_18 n5_18 1
Rv1_10 n1_10 n2_10 1
Rh4_17 n4_17 n4_18 1
Rv17_6 n17_6 n18_6 1
Rv15_13 n15_13 n16_13 1
Rh3_10 n3_10 n3_11 1
Rh5_8 n5_8 n5_9 1
Rv15_14 n15_14 n16_14 1
Rv7_19 n7_19 n8_19 1
Rv10_14 n10_14 n11_14 1
Rv14_8 n14_8 n15_8 1
Rh12_4 n12_4 n12_5 1
Rh17_9 n17_9 n17_10 1
Rv1_17 n1_17 n2_17 1
Rv5_18 n5_18 n6_18 1
Rv13_17 n13_17 n14_17 1
Rv7_14 n7_14 n8_14 1
Rh16_16 n16_16 n16_17 1
Rh7_18 n7_18 n7_19 1
Rh3_18 n3_18 n3_19 1
Rh11_4 n11_4 n11_5 1
Rh12_3 n12_3 n12_4 1
Rv13_12 n13_12 n14_12 1
Rh11_9 n11_9 n11_10 1
Rh17_11 n17_11 n17_12 1
Rh7_9 n7_9 n7_10 1
Rh14_11 n14_11 n14_12 1
Rv8_0 n8_0 n9_0 1
Rv2_1 n2_1 n3_1 1
Rh5_15 n5_15 n5_16 1
Rh16_4 n16_4 n16_5 1
Rv1_5 n1_5 n2_5 1
Rh0_2 n0_2 n0_3 1
Rv16_9 n16_9 n17_9 1
Rh11_0 n11_0 n11_1 1
Rh2_11 n2_11 n2_12 1
Rh19_4 n19_4 n19_5 1
Rh18_6 n18_6 n18_7 1
Rv12_16 n12_16 n13_16 1
Rh1_10 n1_10 n1_11 1
Rh19_10 n19_10 n19_11 1
Rv10_8 n10_8 n11_8 1
Rv8_16 n8_16 n9_16 1
Rv7_17 n7_17 n8_17 1
Rv15_15 n15_15 n16_15 1
Rh19_7 n19_7 n19_8 1
Rv1_16 n1_16 n2_16 1
Rh14_3 n14_3 n14_4 1
Rh7_8 n7_8 n7_9 1
Rh6_4 n6_4 n6_5 1
Rv9_8 n9_8 n10_8 1
Rh12_14 n12_14 n12_15 1
Rv14_1 n14_1 n15_1 1
Rh18_5 n18_5 n18_6 1
Rh3_1 n3_1 n3_2 1
Rh4_0 n4_0 n4_1 1
Rv12_11 n12_11 n13_11 1
Rh15_18 n15_18 n15_19 1
Rh16_7 n16_7 n16_8 1
Rh3_13 n3_13 n3_14 1
Rh3_2 n3_2 n3_3 1
Rv13_8 n13_8 n14_8 1
Rh13_11 n13_11 n13_12 1
Rv17_1 n17_1 n18_1 1
Rv12_9 n12_9 n13_9 1
Rv0_0 n0_0 n1_0 1
Rh6_3 n6_3 n6_4 1
Rv1_0 n1_0 n2_0 1
Rv9_14 n9_14 n10_14 1
Rv6_2 n6_2 n7_2 1
Rv5_19 n5_19 n6_19 1
Rh14_17 n14_17 n14_18 1
Rv16_7 n16_7 n17_7 1
Rh17_14 n17_14 n17_15 1
Rv14_13 n14_13 n15_13 1
Rh2_3 n2_3 n2_4 1
Rv12_5 n12_5 n13_5 1
Rv15_2 n15_2 n16_2 1
Rh18_11 n18_11 n18_12 1
Rh1_0 n1_0 n1_1 1
Rv2_17 n2_17 n3_17 1
Rv5_12 n5_12 n6_12 1
Rh5_5 n5_5 n5_6 1
Rv4_8 n4_8 n5_8 1
Rh4_12 n4_12 n4_13 1
Rv3_18 n3_18 n4_18 1
Rh17_0 n17_0 n17_1 1
Rh14_1 n14_1 n14_2 1
Rh2_0 n2_0 n2_1 1
Rv6_16 n6_16 n7_16 1
Rh2_18 n2_18 n2_19 1
Rh17_5 n17_5 n17_6 1
Rh10_14 n10_14 n10_15 1
Rh12_12 n12_12 n12_13 1
Rh13_2 n13_2 n13_3 1
Rv8_8 n8_8 n9_8 1
Rv5_4 n5_4 n6_4 1
Rh11_8 n11_8 n11_9 1
Rv17_13 n17_13 n18_13 1
Rh14_13 n14_13 n14_14 1
Rv0_14 n0_14 n1_14 1
Rh15_12 n15_12 n15_13 1
Rh15_3 n15_3 n15_4 1
Rv7_9 n7_9 n8_9 1
Rv9_12 n9_12 n10_12 1
Rh9_1 n9_1 n9_2 1
Rh11_1 n11_1 n11_2 1
Rh16_8 n16_8 n16_9 1
Rh10_4 n10_4 n10_5 1
Rh5_10 n5_10 n5_11 1
Rv1_1 n1_1 n2_1 1
Rv8_4 n8_4 n9_4 1
Rh8_9 n8_9 n8_10 1
Rv6_8 n6_8 n7_8 1
Rh8_13 n8_13 n8_14 1
Rv11_1 n11_1 n12_1 1
Rv16_11 n16_11 n17_11 1
Rv4_16 n4_16 n5_16 1
Rv15_9 n15_9 n16_9 1
Rv7_11 n7_11 n8_11 1
Rv10_13 n10_13 n11_13 1
Rv16_16 n16_16 n17_16 1
Rh4_15 n4_15 n4_16 1
Rh0_1 n0_1 n0_2 1
Rh6_12 n6_12 n6_13 1
Rv4_14 n4_14 n5_14 1
Rh6_17 n6_17 n6_18 1
Rh6_16 n6_16 n6_17 1
Rv10_6 n10_6 n11_6 1
Rh0_6 n0_6 n0_7 1
Rv17_17 n17_17 n18_17 1
Rh11_2 n11_2 n11_3 1
Rh17_4 n17_4 n17_5 1
Rv13_2 n13_2 n14_2 1
Rv16_15 n16_15 n17_15 1
Rh3_9 n3_9 n3_10 1
Rv16_17 n16_17 n17_17 1
Rv5_6 n5_6 n6_6 1
Rv12_8 n12_8 n13_8 1
Rv12_3 n12_3 n13_3 1
Rh11_15 n11_15 n11_16 1
Rv15_4 n15_4 n16_4 1
Rh19_2 n19_2 n19_3 1
Rv0_1 n0_1 n1_1 1
Rv8_18 n8_18 n9_18 1
Rv12_4 n12_4 n13_4 1
Rv13_13 n13_13 n14_13 1
Rv2_0 n2_0 n3_0 1
Rh17_3 n17_3 n17_4 1
Rh15_1 n15_1 n15_2 1
Rh19_12 n19_12 n19_13 1
Rh14_5 n14_5 n14_6 1
Rh1_2 n1_2 n1_3 1
Rh8_18 n8_18 n8_19 1
Rh4_8 n4_8 n4_9 1
Rv18_14 n18_14 n19_14 1
Rh0_18 n0_18 n0_19 1
Rh11_14 n11_14 n11_15 1
Rv12_19 n12_19 n13_19 1
Rh10_10 n10_10 n10_11 1
Rh6_5 n6_5 n6_6 1
Rv6_13 n6_13 n7_13 1
Rv0_17 n0_17 n1_17 1
Rh16_2 n16_2 n16_3 1
Rv7_5 n7_5 n8_5 1
Rv18_3 n18_3 n19_3 1
Rv12_1 n12_1 n13_1 1
Rh2_2 n2_2 n2_3 1
Rv13_15 n13_15 n14_15 1
Rv11_15 n11_15 n12_15 1
Rh6_8 n6_8 n6_9 1
Rv3_7 n3_7 n4_7 1
Rv11_0 n11_0 n12_0 1
Rh19_16 n19_16 n19_17 1
Rv15_1 n15_1 n16_1 1
Rh8_1 n8_1 n8_2 1
Rh12_17 n12_17 n12_18 1
Rv4_15 n4_15 n5_15 1
Rv10_18 n10_18 n11_18 1
Rv13_14 n13_14 n14_14 1
Rh13_7 n13_7 n13_8 1
Rh4_11 n4_11 n4_12 1
Rv6_10 n6_10 n7_10 1
Rh0_9 n0_9 n0_10 1
Rv9_10 n9_10 n10_10 1
Rv5_15 n5_15 n6_15 1
Rv18_9 n18_9 n19_9 1
Rv14_5 n14_5 n15_5 1
Rh16_18 n16_18 n16_19 1
Rh5_18 n5_18 n5_19 1
Rh18_8 n18_8 n18_9 1
Rh3_15 n3_15 n3_16 1
Rh13_8 n13_8 n13_9 1
Rh7_5 n7_5 n7_6 1
Rh7_7 n7_7 n7_8 1
Rv3_6 n3_6 n4_6 1
Rh10_13 n10_13 n10_14 1
Rh6_10 n6_10 n6_11 1
Rh16_1 n16_1 n16_2 1
Rh16_3 n16_3 n16_4 1
I4 n10_10 0 DC 1m
Rh10_11 n10_11 n10_12 1
Rv10_10 n10_10 n11_10 1
Rh1_1 n1_1 n1_2 1
Rh18_4 n18_4 n18_5 1
Rv2_8 n2_8 n3_8 1
Rv16_18 n16_18 n17_18 1
Rv4_0 n4_0 n5_0 1
Rh16_13 n16_13 n16_14 1
Rh4_7 n4_7 n4_8 1
Rv2_10 n2_10 n3_10 1
Rh0_15 n0_15 n0_16 1
Rh4_4 n4_4 n4_5 1
Rv14_17 n14_17 n15_17 1
Rv16_6 n16_6 n17_6 1
Rv3_4 n3_4 n4_4 1
Rv14_9 n14_9 n15_9 1
Rh15_8 n15_8 n15_9 1
Rv0_4 n0_4 n1_4 1
Rh1_7 n1_7 n1_8 1
Rv16_13 n16_13 n17_13 1
Rh19_0 n19_0 n19_1 1
Rv2_14 n2_14 n3_14 1
Rv17_5 n17_5 n18_5 1
Rh13_4 n13_4 n13_5 1
Rv6_0 n6_0 n7_0 1
Rv17_16 n17_16 n18_16 1
Rv9_11 n9_11 n10_11 1
Rh16_9 n16_9 n16_10 1
Rh16_12 n16_12 n16_13 1
Rh6_18 n6_18 n6_19 1
Rh8_0 n8_0 n8_1 1
Rh8_14 n8_14 n8_15 1
Rh15_2 n15_2 n15_3 1
Rv5_7 n5_7 n6_7 1
Rv15_18 n15_18 n16_18 1
Rv1_15 n1_15 n2_15 1
Rh18_9 n18_9 n18_10 1
Rh6_0 n6_0 n6_1 1
Rv8_12 n8_12 n9_12 1
Rh14_14 n14_14 n14_15 1
Rv0_8 n0_8 n1_8 1
Rv12_2 n12_2 n13_2 1
Rv5_3 n5_3 n6_3 1
Rh19_15 n19_15 n19_16 1
Rv8_2 n8_2 n9_2 1
Rv3_19 n3_19 n4_19 1
Rv7_0 n7_0 n8_0 1
Rh11_13 n11_13 n11_14 1
Rv3_13 n3_13 n4_13 1
Rh2_17 n2_17 n2_18 1
Rv14_6 n14_6 n15_6 1
Rh3_0 n3_0 n3_1 1
Rh5_12 n5_12 n5_13 1
Rh9_12 n9_12 n9_13 1
Rh8_2 n8_2 n8_3 1
Rh4_9 n4_9 n4_10 1
Rv5_8 n5_8 n6_8 1
Rv6_1 n6_1 n7_1 1
Rh5_2 n5_2 n5_3 1
Rh0_16 n0_16 n0_17 1
Rh19_13 n19_13 n19_14 1
Rv13_19 n13_19 n14_19 1
Rh15_17 n15_17 n15_18 1
Rh5_16 n5_16 n5_17 1
Rv3_11 n3_11 n4_11 1
Rh8_17 n8_17 n8_18 1
Rv7_3 n7_3 n8_3 1
Rh18_0 n18_0 n18_1 1
Rv2_5 n2_5 n3_5 1
Rh4_3 n4_3 n4_4 1
Rh10_0 n10_0 n10_1 1
Rh19_11 n19_11 n19_12 1
Rv17_14 n17_14 n18_14 1
Rh18_15 n18_15 n18_16 1
Rv1_13 n1_13 n2_13 1
Rv0_2 n0_2 n1_2 1
Rv18_0 n18_0 n19_0 1
Rv18_1 n18_1 n19_1 1
Rh9_13 n9_13 n9_14 1
Rv1_7 n1_7 n2_7 1
Rv7_10 n7_10 n8_10 1
Rv2_19 n2_19 n3_19 1
Rh12_2 n12_2 n12_3 1
Rv14_11 n14_11 n15_11 1
Rv12_18 n12_18 n13_18 1
Rv3_2 n3_2 n4_2 1
Rv2_12 n2_12 n3_12 1
Rh9_18 n9_18 n9_19 1
Rh1_14 n1_14 n1_15 1
Rh15_16 n15_16 n15_17 1
Rv4_1 n4_1 n5_1 1
Rh5_4 n5_4 n5_5 1
Rv10_1 n10_1 n11_1 1
Rv14_0 n14_0 n15_0 1
Rv17_19 n17_19 n18_19 1
Rv0_9 n0_9 n1_9 1
Rv2_18 n2_18 n3_18 1
Rv16_14 n16_14 n17_14 1
Rh18_1 n18_1 n18_2 1
Rh14_15 n14_15 n14_16 1
Rh3_6 n3_6 n3_7 1
Rh9_7 n9_7 n9_8 1
Rh10_5 n10_5 n10_6 1
Rh0_12 n0_12 n0_13 1
Rv4_17 n4_17 n5_17 1
Rv12_13 n12_13 n13_13 1
Rv7_7 n7_7 n8_7 1
Rv8_7 n8_7 n9_7 1
Rv14_16 n14_16 n15_16 1
Rh9_16 n9_16 n9_17 1
Rh0_17 n0_17 n0_18 1
Rv18_17 n18_17 n19_17 1
Rh10_6 n10_6 n10_7 1
Rh8_8 n8_8 n8_9 1
Rv9_3 n9_3 n10_3 1
Rv8_5 n8_5 n9_5 1
Rv2_11 n2_11 n3_11 1
Rv9_18 n9_18 n10_18 1
Rpad2 vdd n19_0 0.01
Rv9_6 n9_6 n10_6 1
Rv11_17 n11_17 n12_17 1
Rv9_13 n9_13 n10_13 1
Rh14_12 n14_12 n14_13 1
Rh4_5 n4_5 n4_6 1
Rh14_9 n14_9 n14_10 1
I8 n16_16 0 DC 1m
Rh0_0 n0_0 n0_1 1
Rv6_9 n6_9 n7_9 1
Rv8_15 n8_15 n9_15 1
Rv9_2 n9_2 n10_2 1
Rh7_11 n7_11 n7_12 1
Rv11_6 n11_6 n12_6 1
Rv8_13 n8_13 n9_13 1
Rv13_4 n13_4 n14_4 1
Rv10_9 n10_9 n11_9 1
Rv15_6 n15_6 n16_6 1
Rh6_14 n6_14 n6_15 1
Rv1_14 n1_14 n2_14 1
Rv9_5 n9_5 n10_5 1
Rh15_0 n15_0 n15_1 1
Rh15_4 n15_4 n15_5 1
Rv6_18 n6_18 n7_18 1
Rv10_7 n10_7 n11_7 1
Rv3_12 n3_12 n4_12 1
Rv15_17 n15_17 n16_17 1
Rv18_19 n18_19 n19_19 1
Rv11_5 n11_5 n12_5 1
Rv5_0 n5_0 n6_0 1
Rh13_1 n13_1 n13_2 1
Rv10_16 n10_16 n11_16 1
Rv2_4 n2_4 n3_4 1
Rv0_18 n0_18 n1_18 1
Rh18_13 n18_13 n18_14 1
Rh14_4 n14_4 n14_5 1
Rv0_7 n0_7 n1_7 1
Rh18_12 n18_12 n18_13 1
Rh1_8 n1_8 n1_9 1
Rv17_4 n17_4 n18_4 1
Rv5_17 n5_17 n6_17 1
Rv3_5 n3_5 n4_5 1
Rh13_14 n13_14 n13_15 1
Rv8_19 n8_19 n9_19 1
Rv13_16 n13_16 n14_16 1
Rh12_1 n12_1 n12_2 1
Rh0_11 n0_11 n0_12 1
Rh17_10 n17_10 n17_11 1
Rv13_3 n13_3 n14_3 1
Rv16_8 n16_8 n17_8 1
Rh19_17 n19_17 n19_18 1
Rh17_17 n17_17 n17_18 1
Rv13_18 n13_18 n14_18 1
Rv13_1 n13_1 n14_1 1
Rh6_11 n6_11 n6_12 1
Rh13_13 n13_13 n13_14 1
Rh16_15 n16_15 n16_16 1
Rv18_11 n18_11 n19_11 1
Rh5_7 n5_7 n5_8 1
Rv15_12 n15_12 n16_12 1
Rv2_9 n2_9 n3_9 1
Rv10_17 n10_17 n11_17 1
Rv3_8 n3_8 n4_8 1
I2 n3_16 0 DC 1m
Rv17_12 n17_12 n18_12 1
Rh9_10 n9_10 n9_11 1
Rv10_0 n10_0 n11_0 1
Rh12_11 n12_11 n12_12 1
Rh6_7 n6_7 n6_8 1
Rh14_16 n14_16 n14_17 1
Rh17_2 n17_2 n17_3 1
Rv15_3 n15_3 n16_3 1
Rh7_4 n7_4 n7_5 1
Rv18_18 n18_18 n19_18 1
Rh17_13 n17_13 n17_14 1
Rh3_16 n3_16 n3_17 1
Rh15_11 n15_11 n15_12 1
Rh7_12 n7_12 n7_13 1
Rh17_16 n17_16 n17_17 1
Rh17_1 n17_1 n17_2 1
Rv9_9 n9_9 n10_9 1
Rv13_11 n13_11 n14_11 1
Rh11_6 n11_6 n11_7 1
Rv6_11 n6_11 n7_11 1
Rh16_6 n16_6 n16_7 1
Rh16_0 n16_0 n16_1 1
Rv16_3 n16_3 n17_3 1
I6 n16_3 0 DC 1m
Rv14_12 n14_12 n15_12 1
Rv18_13 n18_13 n19_13 1
Rv11_7 n11_7 n12_7 1
Rv18_5 n18_5 n19_5 1
Rv12_6 n12_6 n13_6 1
Rv1_4 n1_4 n2_4 1
Rh4_16 n4_16 n4_17 1
Rv4_5 n4_5 n5_5 1
Rv4_13 n4_13 n5_13 1
Rh9_17 n9_17 n9_18 1
Rv16_1 n16_1 n17_1 1
Rh10_3 n10_3 n10_4 1
Rv7_4 n7_4 n8_4 1
Rh12_13 n12_13 n12_14 1
Rh5_11 n5_11 n5_12 1
Rh3_14 n3_14 n3_15 1
Rh19_5 n19_5 n19_6 1
Rv0_10 n0_10 n1_10 1
Rv12_17 n12_17 n13_17 1
Rh15_10 n15_10 n15_11 1
Rh10_18 n10_18 n10_19 1
Rh15_9 n15_9 n15_10 1
Rh18_10 n18_10 n18_11 1
Rv9_17 n9_17 n10_17 1
Rv14_19 n14_19 n15_19 1
Rv13_0 n13_0 n14_0 1
Rh9_6 n9_6 n9_7 1
Rv8_9 n8_9 n9_9 1
Rv11_16 n11_16 n12_16 1
Rv5_14 n5_14 n6_14 1
Rv2_6 n2_6 n3_6 1
Rh10_15 n10_15 n10_16 1
Rv3_15 n3_15 n4_15 1
Rv8_3 n8_3 n9_3 1
Rh6_9 n6_9 n6_10 1
I0 n3_3 0 DC 1m
Rh13_3 n13_3 n13_4 1
Rv11_13 n11_13 n12_13 1
Rh8_15 n8_15 n8_16 1
Rv14_18 n14_18 n15_18 1
Rv5_5 n5_5 n6_5 1
Rh13_12 n13_12 n13_13 1
Rh16_5 n16_5 n16_6 1
Rh2_15 n2_15 n2_16 1
Rv15_7 n15_7 n16_7 1
Rv7_1 n7_1 n8_1 1
Rv11_10 n11_10 n12_10 1
Rh5_17 n5_17 n5_18 1
Rh8_4 n8_4 n8_5 1
Rh0_7 n0_7 n0_8 1
I5 n10_16 0 DC 1m
Rv3_10 n3_10 n4_10 1
Rv10_11 n10_11 n11_11 1
Rv16_19 n16_19 n17_19 1
Rv14_7 n14_7 n15_7 1
Rh7_3 n7_3 n7_4 1
Rh10_12 n10_12 n10_13 1
Rv17_3 n17_3 n18_3 1
Rv1_11 n1_11 n2_11 1
Rv0_3 n0_3 n1_3 1
Rv13_6 n13_6 n14_6 1
Rv0_11 n0_11 n1_11 1
Rh14_10 n14_10 n14_11 1
Rv5_16 n5_16 n6_16 1
Rv8_6 n8_6 n9_6 1
Rh12_16 n12_16 n12_17 1
Rh18_7 n18_7 n18_8 1
Rv5_11 n5_11 n6_11 1
Rpad3 vdd n19_19 0.01
Rh3_17 n3_17 n3_18 1
Rh8_16 n8_16 n8_17 1
Rv17_15 n17_15 n18_15 1
Rh5_3 n5_3 n5_4 1
Rv9_16 n9_16 n10_16 1
Rv4_11 n4_11 n5_11 1
Rv8_14 n8_14 n9_14 1
Rh16_10 n16_10 n16_11 1
Rh4_18 n4_18 n4_19 1
Rh6_15 n6_15 n6_16 1
Rh13_18 n13_18 n13_19 1
Rh13_15 n13_15 n13_16 1
Rv3_0 n3_0 n4_0 1
Rh4_2 n4_2 n4_3 1
Rv17_7 n17_7 n18_7 1
Rh14_6 n14_6 n14_7 1
Rh13_9 n13_9 n13_10 1
Rh13_10 n13_10 n13_11 1
Rh17_18 n17_18 n17_19 1
Rv2_3 n2_3 n3_3 1
Rv0_19 n0_19 n1_19 1
Rh17_8 n17_8 n17_9 1
Rv9_15 n9_15 n10_15 1
Rv1_18 n1_18 n2_18 1
Rv17_2 n17_2 n18_2 1
Rh0_8 n0_8 n0_9 1
Rv6_17 n6_17 n7_17 1
Rv10_5 n10_5 n11_5 1
Rh4_6 n4_6 n4_7 1
Rv11_12 n11_12 n12_12 1
Rh12_10 n12_10 n12_11 1
Rh7_2 n7_2 n7_3 1
Rh16_14 n16_14 n16_15 1
Rv18_6 n18_6 n19_6 1
Rv1_9 n1_9 n2_9 1
Rh13_16 n13_16 n13_17 1
Rh11_18 n11_18 n11_19 1
Rh2_12 n2_12 n2_13 1
Rh6_6 n6_6 n6_7 1
Rv10_2 n10_2 n11_2 1
Rh11_12 n11_12 n11_13 1
Rh12_18 n12_18 n12_19 1
Rv12_10 n12_10 n13_10 1
Rh2_4 n2_4 n2_5 1
Rh10_7 n10_7 n10_8 1
Rv10_15 n10_15 n11_15 1
Rh13_5 n13_5 n13_6 1
Rh11_3 n11_3 n11_4 1
Rh19_8 n19_8 n19_9 1
Rv4_2 n4_2 n5_2 1
Rh13_17 n13_17 n13_18 1
Rv3_17 n3_17 n4_17 1
Rv18_15 n18_15 n19_15 1
Rv10_4 n10_4 n11_4 1
Rv16_10 n16_10 n17_10 1
Rh10_17 n10_17 n10_18 1
Rh1_4 n1_4 n1_5 1
Rv15_10 n15_10 n16_10 1
Rpad1 vdd n0_19 0.01
Rv0_5 n0_5 n1_5 1
Rh14_7 n14_7 n14_8 1
Rv18_8 n18_8 n19_8 1
Rh9_11 n9_11 n9_12 1
Rh13_6 n13_6 n13_7 1
Rv9_7 n9_7 n10_7 1
Rv2_16 n2_16 n3_16 1
Rh12_0 n12_0 n12_1 1
I3 n10_3 0 DC 1m
Rh2_9 n2_9 n2_10 1
Rh1_6 n1_6 n1_7 1
Rv5_2 n5_2 n6_2 1
Rh7_15 n7_15 n7_16 1
Rv18_7 n18_7 n19_7 1
Rv7_18 n7_18 n8_18 1
Rh3_11 n3_11 n3_12 1
Rh4_14 n4_14 n4_15 1
Rv4_10 n4_10 n5_10 1
Rh5_13 n5_13 n5_14 1
Rh2_8 n2_8 n2_9 1
Rh10_2 n10_2 n10_3 1
Rv0_12 n0_12 n1_12 1
Rv17_0 n17_0 n18_0 1
Rv5_1 n5_1 n6_1 1
Rh7_0 n7_0 n7_1 1
Rv18_12 n18_12 n19_12 1
Rh3_5 n3_5 n3_6 1
Rh2_1 n2_1 n2_2 1
.op
.end
