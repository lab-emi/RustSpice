Resistor mesh 18x18, link R log-uniform 1e-2..1e2 ohm (conductance contrast 1e4), randomly numbered (seed 67)
* bench.id: acc_dc_mesh_rand_contrast4_m18
* bench.group: accuracy
* bench.title: Resistor mesh 18x18, link R log-uniform 1e-2..1e2 ohm (conductance contrast 1e4), randomly numbered (seed 67)
* bench.expect: match
* bench.oracle: dc_linear
* bench.size: 325
* bench.tags: linear, op, mesh, random_numbering, ill_conditioned, wide_ratio
* bench.note: probes: every node voltage (default); default tolerances. The matrix is moderately conditioned (cond2 = 1.4e5; a dense f64 LU of it agrees with ngspice to 4.6e-13 V), so the lost digits come from the elimination order of the static pivoting, not from conditioning; independent check: dense f64 solve of the deck's own MNA system and the KCL residual of both answers (RustSpice 1.9e-5 A, ngspice 5.7e-14 A).
Rv7_4 n7_4 n8_4 0.035349
Rh15_10 n15_10 n15_11 0.012083
Rh13_8 n13_8 n13_9 0.03325
Rh6_16 n6_16 n6_17 0.015911
Rh5_7 n5_7 n5_8 2.0509
Rh13_9 n13_9 n13_10 4.7168
Rh10_12 n10_12 n10_13 0.020049
Rv15_3 n15_3 n16_3 0.83831
Rv0_0 n0_0 n1_0 11.588
Rv6_15 n6_15 n7_15 0.98093
I5 n9_15 0 DC 1m
Rv11_3 n11_3 n12_3 0.0178
Rh0_12 n0_12 n0_13 0.30451
Rv9_8 n9_8 n10_8 4.446
Rv1_10 n1_10 n2_10 6.2086
Rh9_2 n9_2 n9_3 6.1556
Rh12_7 n12_7 n12_8 0.058474
Rh12_9 n12_9 n12_10 0.026327
Rh15_1 n15_1 n15_2 0.12513
Rh10_15 n10_15 n10_16 0.026067
Rh2_3 n2_3 n2_4 12.158
Rv8_2 n8_2 n9_2 0.28112
Rv3_13 n3_13 n4_13 0.01306
Rv14_0 n14_0 n15_0 0.069562
Rh2_13 n2_13 n2_14 0.040347
Rh3_1 n3_1 n3_2 3.0792
Rv3_17 n3_17 n4_17 0.17914
Rh3_13 n3_13 n3_14 0.089216
Rv6_2 n6_2 n7_2 7.2783
I7 n15_9 0 DC 1m
Rh14_7 n14_7 n14_8 0.88642
Rv2_4 n2_4 n3_4 0.6973
Rh7_11 n7_11 n7_12 0.020893
Rv0_11 n0_11 n1_11 0.04082
Rv13_2 n13_2 n14_2 0.16586
Rv11_11 n11_11 n12_11 0.8431
Rh17_6 n17_6 n17_7 0.086081
Rv9_9 n9_9 n10_9 0.039514
Rv9_17 n9_17 n10_17 65.93
Rv13_9 n13_9 n14_9 3.2634
Rv10_4 n10_4 n11_4 0.24594
Rv16_3 n16_3 n17_3 0.51815
Rh12_6 n12_6 n12_7 0.011942
Rv0_13 n0_13 n1_13 11.397
Rv16_2 n16_2 n17_2 11.755
Rh15_7 n15_7 n15_8 8.7229
Rh10_10 n10_10 n10_11 3.3576
Rh2_12 n2_12 n2_13 5.7491
Rv13_1 n13_1 n14_1 0.016195
Rv0_14 n0_14 n1_14 4.009
Rh5_13 n5_13 n5_14 1.3715
Rv7_15 n7_15 n8_15 0.13214
Rv8_0 n8_0 n9_0 1.7131
Rv6_0 n6_0 n7_0 0.07005
Rv15_13 n15_13 n16_13 0.30529
Rv12_1 n12_1 n13_1 34.942
Rh17_13 n17_13 n17_14 45.853
Rh13_5 n13_5 n13_6 0.082223
Rv2_0 n2_0 n3_0 5.2605
Rh1_5 n1_5 n1_6 0.38381
Rh5_9 n5_9 n5_10 0.011429
Rh2_2 n2_2 n2_3 0.27526
Rv10_5 n10_5 n11_5 17.432
Rh2_7 n2_7 n2_8 1.4199
Rv11_13 n11_13 n12_13 2.5741
Rh8_11 n8_11 n8_12 0.13269
Rv15_0 n15_0 n16_0 0.025221
Rh5_0 n5_0 n5_1 67.931
Rv7_8 n7_8 n8_8 5.027
Rv2_12 n2_12 n3_12 0.07942
Rh15_16 n15_16 n15_17 1.3472
Rv1_6 n1_6 n2_6 1.993
Rh1_9 n1_9 n1_10 63.629
Rh6_10 n6_10 n6_11 7.4491
Rh7_3 n7_3 n7_4 0.38193
Rh13_0 n13_0 n13_1 0.29772
Rh6_12 n6_12 n6_13 74.864
Rv11_12 n11_12 n12_12 0.19516
Rv12_15 n12_15 n13_15 0.017261
Rv3_15 n3_15 n4_15 1.7348
Rh8_16 n8_16 n8_17 28.184
Rv7_5 n7_5 n8_5 0.060257
Rv16_15 n16_15 n17_15 0.052378
Rh9_1 n9_1 n9_2 3.8664
Rv16_8 n16_8 n17_8 19.206
Rv6_6 n6_6 n7_6 0.13786
Rh17_4 n17_4 n17_5 5.5958
Rh16_3 n16_3 n16_4 0.030872
Rh3_9 n3_9 n3_10 21.863
Rh9_5 n9_5 n9_6 1.7919
Rv5_12 n5_12 n6_12 7.7463
Rv3_2 n3_2 n4_2 0.26059
Rh0_13 n0_13 n0_14 75.149
Rv12_3 n12_3 n13_3 6.4247
Rh4_1 n4_1 n4_2 0.018752
Rh7_16 n7_16 n7_17 3.614
Rv15_15 n15_15 n16_15 0.30828
Rv4_16 n4_16 n5_16 1.4505
Rv1_4 n1_4 n2_4 0.57166
Rv5_11 n5_11 n6_11 3.9288
Rv12_4 n12_4 n13_4 0.46649
Rv9_6 n9_6 n10_6 0.072187
Rh0_0 n0_0 n0_1 0.019915
Rv11_10 n11_10 n12_10 0.091124
Rh8_10 n8_10 n8_11 0.69986
Rh8_0 n8_0 n8_1 1.4277
Rh0_4 n0_4 n0_5 0.065316
Rv14_4 n14_4 n15_4 16.69
Rv5_10 n5_10 n6_10 24.24
Rv11_8 n11_8 n12_8 0.023415
Rv13_16 n13_16 n14_16 1.9574
Rh6_14 n6_14 n6_15 1.8943
Rh12_11 n12_11 n12_12 1.2152
Rh6_7 n6_7 n6_8 10.429
Rv12_10 n12_10 n13_10 3.5177
Rv8_6 n8_6 n9_6 0.080662
Rv9_12 n9_12 n10_12 48.626
Rv7_11 n7_11 n8_11 0.027463
Rh0_11 n0_11 n0_12 0.043888
Rh9_6 n9_6 n9_7 0.17787
Rh11_3 n11_3 n11_4 0.20469
Rh10_2 n10_2 n10_3 1.0116
Rv5_0 n5_0 n6_0 2.1471
Rh6_5 n6_5 n6_6 0.038441
Rh3_12 n3_12 n3_13 0.17334
Rv13_7 n13_7 n14_7 35.813
Rh15_0 n15_0 n15_1 0.067765
Rh8_12 n8_12 n8_13 4.1486
Rh14_2 n14_2 n14_3 0.17984
Rh14_12 n14_12 n14_13 0.036397
Rv1_2 n1_2 n2_2 2.6335
V1 vdd 0 DC 1.0
Rv2_2 n2_2 n3_2 3.9459
Rh7_5 n7_5 n7_6 0.49613
Rh12_14 n12_14 n12_15 0.23246
I1 n3_9 0 DC 1m
Rh9_10 n9_10 n9_11 2.8219
Rh3_6 n3_6 n3_7 38.704
Rh15_3 n15_3 n15_4 0.024324
Rh14_11 n14_11 n14_12 0.038094
Rv5_5 n5_5 n6_5 0.065815
Rv12_14 n12_14 n13_14 0.10878
Rv2_14 n2_14 n3_14 68.015
Rh12_10 n12_10 n12_11 1.2412
Rv4_5 n4_5 n5_5 0.43037
Rv13_4 n13_4 n14_4 1.5365
Rh11_16 n11_16 n11_17 4.6253
Rv0_7 n0_7 n1_7 0.17095
Rh2_10 n2_10 n2_11 13.995
Rv3_8 n3_8 n4_8 56.417
Rv15_5 n15_5 n16_5 8.3661
Rh15_13 n15_13 n15_14 0.024252
Rv15_16 n15_16 n16_16 0.014035
Rv8_14 n8_14 n9_14 45.737
Rh8_14 n8_14 n8_15 3.4725
Rh1_12 n1_12 n1_13 0.3361
Rh12_12 n12_12 n12_13 5.6546
Rv12_9 n12_9 n13_9 86.565
Rv1_9 n1_9 n2_9 0.5107
Rpad0 vdd n0_0 0.01
Rh0_14 n0_14 n0_15 17.144
Rv13_10 n13_10 n14_10 1.8118
Rv10_11 n10_11 n11_11 0.52191
Rv0_17 n0_17 n1_17 0.55038
Rh1_13 n1_13 n1_14 31.657
Rh3_3 n3_3 n3_4 69.526
Rv10_15 n10_15 n11_15 96.834
Rv13_15 n13_15 n14_15 9.5342
Rh17_15 n17_15 n17_16 7.5541
Rv4_4 n4_4 n5_4 0.018089
Rh7_10 n7_10 n7_11 0.011963
Rh12_0 n12_0 n12_1 16.286
Rv14_9 n14_9 n15_9 0.50443
Rh17_8 n17_8 n17_9 3.4031
Rh12_4 n12_4 n12_5 0.53707
Rv14_16 n14_16 n15_16 0.92115
Rh8_9 n8_9 n8_10 16.29
Rh1_16 n1_16 n1_17 0.84488
Rh4_7 n4_7 n4_8 53.531
Rv1_5 n1_5 n2_5 0.012551
Rh4_0 n4_0 n4_1 35.52
Rh11_9 n11_9 n11_10 0.015339
I6 n15_3 0 DC 1m
Rh1_1 n1_1 n1_2 26.545
Rv4_13 n4_13 n5_13 0.42812
Rv0_4 n0_4 n1_4 0.01442
Rh7_9 n7_9 n7_10 0.021423
Rv1_14 n1_14 n2_14 0.66089
Rh11_12 n11_12 n11_13 0.28684
Rv11_9 n11_9 n12_9 0.18381
Rv14_17 n14_17 n15_17 38.287
Rh11_11 n11_11 n11_12 68.33
Rh11_6 n11_6 n11_7 0.018853
Rh17_16 n17_16 n17_17 0.068616
Rv5_13 n5_13 n6_13 1.5977
Rh14_9 n14_9 n14_10 0.10975
Rv4_6 n4_6 n5_6 0.21281
Rh6_4 n6_4 n6_5 12.624
Rh0_8 n0_8 n0_9 0.40069
Rh16_11 n16_11 n16_12 87.921
Rv7_17 n7_17 n8_17 0.040582
Rv16_16 n16_16 n17_16 1.5332
Rh13_15 n13_15 n13_16 0.011618
Rh10_9 n10_9 n10_10 0.17182
Rv10_7 n10_7 n11_7 0.62843
Rv0_3 n0_3 n1_3 47.623
Rv1_17 n1_17 n2_17 2.2142
Rh14_1 n14_1 n14_2 94.58
Rv9_4 n9_4 n10_4 17.002
Rv3_16 n3_16 n4_16 0.019219
Rv13_3 n13_3 n14_3 71.086
Rv5_6 n5_6 n6_6 0.59176
Rh2_16 n2_16 n2_17 4.425
Rh7_1 n7_1 n7_2 13.039
Rh5_5 n5_5 n5_6 0.016276
Rv12_7 n12_7 n13_7 0.20218
Rh16_7 n16_7 n16_8 1.2033
Rh8_13 n8_13 n8_14 3.3914
Rh9_13 n9_13 n9_14 0.091127
Rh15_6 n15_6 n15_7 0.092549
Rh12_5 n12_5 n12_6 0.047962
Rh9_9 n9_9 n9_10 19.739
Rv2_16 n2_16 n3_16 5.5552
Rv8_5 n8_5 n9_5 0.053245
Rh17_5 n17_5 n17_6 0.52776
Rv2_6 n2_6 n3_6 4.5918
Rh0_7 n0_7 n0_8 0.024103
Rv8_10 n8_10 n9_10 12.117
Rv0_15 n0_15 n1_15 0.35924
Rh3_16 n3_16 n3_17 7.3145
Rv7_13 n7_13 n8_13 0.029112
Rv14_6 n14_6 n15_6 5.0959
Rv4_9 n4_9 n5_9 0.68113
Rh8_5 n8_5 n8_6 0.023593
Rv14_15 n14_15 n15_15 0.017214
Rh16_6 n16_6 n16_7 0.29877
Rh4_15 n4_15 n4_16 17.958
Rh11_0 n11_0 n11_1 0.31222
Rh9_4 n9_4 n9_5 0.66774
Rv1_12 n1_12 n2_12 87.45
Rh14_5 n14_5 n14_6 18.091
Rh8_15 n8_15 n8_16 2.4347
Rh7_14 n7_14 n7_15 9.7993
Rh1_15 n1_15 n1_16 0.87976
Rh13_10 n13_10 n13_11 90
Rh4_6 n4_6 n4_7 0.063973
Rh10_13 n10_13 n10_14 1.3171
Rh3_7 n3_7 n3_8 0.14328
Rv7_16 n7_16 n8_16 0.01497
Rv3_9 n3_9 n4_9 0.63826
Rh2_0 n2_0 n2_1 7.2754
Rh16_5 n16_5 n16_6 12.493
Rv16_5 n16_5 n17_5 0.088431
Rh15_5 n15_5 n15_6 0.011245
Rh3_14 n3_14 n3_15 8.9557
Rv5_1 n5_1 n6_1 2.4065
Rh7_4 n7_4 n7_5 8.5795
Rh9_15 n9_15 n9_16 0.075125
Rv6_9 n6_9 n7_9 2.5749
Rh9_7 n9_7 n9_8 0.13286
Rv0_9 n0_9 n1_9 3.9786
Rv15_17 n15_17 n16_17 0.015182
Rv14_11 n14_11 n15_11 4.8643
Rh3_15 n3_15 n3_16 0.011302
Rh13_11 n13_11 n13_12 0.75363
Rv2_11 n2_11 n3_11 0.017084
Rv13_8 n13_8 n14_8 0.23353
Rv16_13 n16_13 n17_13 3.0584
Rv6_12 n6_12 n7_12 1.1023
Rh4_14 n4_14 n4_15 1.4268
Rv12_6 n12_6 n13_6 0.06392
Rv16_10 n16_10 n17_10 0.014398
Rv10_8 n10_8 n11_8 0.063934
Rv6_7 n6_7 n7_7 1.0905
Rh13_16 n13_16 n13_17 15.936
Rh6_1 n6_1 n6_2 1.695
Rv10_14 n10_14 n11_14 0.011067
Rv0_12 n0_12 n1_12 0.010623
Rv12_8 n12_8 n13_8 11.83
Rv5_2 n5_2 n6_2 7.1059
Rv10_10 n10_10 n11_10 0.011614
Rv10_12 n10_12 n11_12 91.808
Rpad3 vdd n17_17 0.01
Rv1_11 n1_11 n2_11 69.876
Rh13_4 n13_4 n13_5 9.5124
Rv11_5 n11_5 n12_5 0.12224
Rv2_15 n2_15 n3_15 64.533
Rv7_1 n7_1 n8_1 7.7402
Rv1_7 n1_7 n2_7 0.057731
Rh16_14 n16_14 n16_15 2.2573
Rv9_2 n9_2 n10_2 10.273
Rh14_8 n14_8 n14_9 0.44256
Rh7_13 n7_13 n7_14 2.8704
Rv14_12 n14_12 n15_12 77.063
Rv11_14 n11_14 n12_14 18.537
Rv0_5 n0_5 n1_5 0.013802
Rv2_13 n2_13 n3_13 10.704
Rv13_5 n13_5 n14_5 83.759
Rv13_12 n13_12 n14_12 0.952
Rv8_9 n8_9 n9_9 27.65
Rh14_10 n14_10 n14_11 1.0954
Rv7_12 n7_12 n8_12 46.132
Rv13_11 n13_11 n14_11 2.8564
Rv15_8 n15_8 n16_8 3.7084
Rv5_15 n5_15 n6_15 45.355
Rh4_4 n4_4 n4_5 0.016978
Rv14_1 n14_1 n15_1 49.174
Rv8_3 n8_3 n9_3 0.0391
Rv9_15 n9_15 n10_15 21.568
Rh11_15 n11_15 n11_16 0.27458
Rv8_12 n8_12 n9_12 0.015634
Rv14_13 n14_13 n15_13 3.1823
Rv4_0 n4_0 n5_0 2.1747
Rv10_17 n10_17 n11_17 2.447
Rh11_7 n11_7 n11_8 0.01465
Rv3_5 n3_5 n4_5 0.023979
Rv8_16 n8_16 n9_16 0.2628
Rv12_12 n12_12 n13_12 15.82
Rv4_15 n4_15 n5_15 1.2833
Rh13_1 n13_1 n13_2 0.42224
Rh7_12 n7_12 n7_13 5.2668
Rv3_10 n3_10 n4_10 21.295
Rv10_2 n10_2 n11_2 1.4616
Rv8_7 n8_7 n9_7 19.93
Rh3_5 n3_5 n3_6 0.025125
Rh1_2 n1_2 n1_3 0.012708
Rv9_0 n9_0 n10_0 46.953
Rv0_6 n0_6 n1_6 0.031051
Rh4_11 n4_11 n4_12 3.0507
Rh15_2 n15_2 n15_3 91.68
Rv1_8 n1_8 n2_8 5.8845
Rh5_3 n5_3 n5_4 0.039735
Rh13_2 n13_2 n13_3 6.4806
Rh6_2 n6_2 n6_3 0.016147
Rh10_14 n10_14 n10_15 2.9449
Rh1_6 n1_6 n1_7 30.782
Rh11_4 n11_4 n11_5 54.583
Rv5_7 n5_7 n6_7 2.9635
I0 n3_3 0 DC 1m
Rv11_17 n11_17 n12_17 1.4458
Rh13_6 n13_6 n13_7 0.28084
Rv5_14 n5_14 n6_14 5.9726
Rh17_11 n17_11 n17_12 16.243
Rh5_14 n5_14 n5_15 0.46955
Rh5_11 n5_11 n5_12 8.8203
Rh17_3 n17_3 n17_4 0.11469
Rh5_2 n5_2 n5_3 1.4066
Rh10_3 n10_3 n10_4 0.78985
Rh15_4 n15_4 n15_5 0.59465
Rh2_9 n2_9 n2_10 3.7731
Rh14_6 n14_6 n14_7 0.01167
Rv2_10 n2_10 n3_10 3.0921
Rv7_14 n7_14 n8_14 0.020516
Rh13_3 n13_3 n13_4 0.23164
Rh10_4 n10_4 n10_5 51.496
Rh6_3 n6_3 n6_4 19.84
Rh11_2 n11_2 n11_3 31.898
Rv5_17 n5_17 n6_17 1.5241
Rh15_12 n15_12 n15_13 4.4127
Rh16_4 n16_4 n16_5 25.031
Rv9_13 n9_13 n10_13 0.030416
Rh14_3 n14_3 n14_4 81.892
Rv6_16 n6_16 n7_16 5.7144
Rv11_7 n11_7 n12_7 19.024
Rv15_9 n15_9 n16_9 57.75
Rv3_7 n3_7 n4_7 9.4445
Rv6_17 n6_17 n7_17 13.099
Rv16_4 n16_4 n17_4 29.674
Rh7_6 n7_6 n7_7 6.2854
Rh8_2 n8_2 n8_3 0.26344
Rh2_11 n2_11 n2_12 10.97
Rh5_10 n5_10 n5_11 2.1311
Rv4_17 n4_17 n5_17 0.083813
Rv11_6 n11_6 n12_6 0.13553
Rv3_3 n3_3 n4_3 0.062389
Rh4_2 n4_2 n4_3 0.096818
Rh12_13 n12_13 n12_14 3.5467
Rh11_5 n11_5 n11_6 8.5814
Rh4_9 n4_9 n4_10 0.22313
Rh3_11 n3_11 n3_12 5.4535
Rv16_12 n16_12 n17_12 33.314
Rv6_14 n6_14 n7_14 1.7537
Rh15_15 n15_15 n15_16 0.013629
Rh17_14 n17_14 n17_15 0.22291
Rh2_5 n2_5 n2_6 0.036034
Rv5_9 n5_9 n6_9 29.967
Rv9_1 n9_1 n10_1 25.92
Rv2_8 n2_8 n3_8 0.011686
Rh3_8 n3_8 n3_9 0.17117
Rv7_6 n7_6 n8_6 0.41081
Rv8_1 n8_1 n9_1 0.062193
Rh7_15 n7_15 n7_16 21.483
Rv15_2 n15_2 n16_2 21.37
Rh16_9 n16_9 n16_10 33.6
Rh10_8 n10_8 n10_9 3.9271
Rh16_2 n16_2 n16_3 3.0688
Rh2_6 n2_6 n2_7 11.987
Rh5_15 n5_15 n5_16 37.843
Rv14_8 n14_8 n15_8 24.793
Rh14_13 n14_13 n14_14 27.275
Rh7_7 n7_7 n7_8 63.417
Rv6_5 n6_5 n7_5 0.10496
Rv7_3 n7_3 n8_3 0.014398
Rh6_13 n6_13 n6_14 0.17277
Rv14_10 n14_10 n15_10 0.5544
Rh1_7 n1_7 n1_8 0.034285
Rh14_14 n14_14 n14_15 5.2396
I3 n9_3 0 DC 1m
Rh4_10 n4_10 n4_11 3.5504
Rh4_3 n4_3 n4_4 81.402
Rh13_13 n13_13 n13_14 0.030353
Rv11_2 n11_2 n12_2 32.686
I2 n3_15 0 DC 1m
Rv8_15 n8_15 n9_15 0.50405
Rh5_16 n5_16 n5_17 53.724
Rv13_13 n13_13 n14_13 37.053
Rv14_7 n14_7 n15_7 35.59
Rh2_15 n2_15 n2_16 0.24284
Rv8_4 n8_4 n9_4 0.093538
Rh16_10 n16_10 n16_11 27.831
Rv7_10 n7_10 n8_10 2.3024
Rv3_11 n3_11 n4_11 54.732
Rh6_9 n6_9 n6_10 0.15242
Rv5_16 n5_16 n6_16 0.018107
Rh1_10 n1_10 n1_11 1.5463
Rv12_17 n12_17 n13_17 9.4994
Rv13_17 n13_17 n14_17 14.181
Rh16_12 n16_12 n16_13 0.020285
Rh8_4 n8_4 n8_5 36.034
Rh0_9 n0_9 n0_10 0.011242
Rh2_8 n2_8 n2_9 2.5131
Rh6_11 n6_11 n6_12 0.030468
Rv13_6 n13_6 n14_6 0.014656
Rh7_8 n7_8 n7_9 0.67379
Rv4_7 n4_7 n5_7 0.074757
Rv16_17 n16_17 n17_17 90.181
Rv14_14 n14_14 n15_14 0.084466
Rh4_16 n4_16 n4_17 33.095
Rh7_2 n7_2 n7_3 0.042603
Rv9_14 n9_14 n10_14 39.88
Rh4_12 n4_12 n4_13 0.01029
Rh0_5 n0_5 n0_6 0.050943
Rh2_1 n2_1 n2_2 16.859
Rh3_4 n3_4 n3_5 20.632
Rv1_3 n1_3 n2_3 2.7018
Rv8_13 n8_13 n9_13 0.46596
Rh0_16 n0_16 n0_17 0.014567
Rh17_9 n17_9 n17_10 0.56998
Rv13_0 n13_0 n14_0 3.8757
Rh10_7 n10_7 n10_8 18.266
Rh1_8 n1_8 n1_9 1.4171
Rh5_6 n5_6 n5_7 12.07
Rh16_15 n16_15 n16_16 0.03249
Rv11_0 n11_0 n12_0 0.043796
Rv15_10 n15_10 n16_10 0.035769
Rv5_8 n5_8 n6_8 0.010761
Rh10_1 n10_1 n10_2 0.19654
Rv15_14 n15_14 n16_14 1.7937
Rh3_10 n3_10 n3_11 5.9831
Rh11_13 n11_13 n11_14 0.10338
Rv8_8 n8_8 n9_8 0.14376
Rv14_5 n14_5 n15_5 0.015532
Rv10_13 n10_13 n11_13 0.18051
Rv6_13 n6_13 n7_13 1.0084
I4 n9_9 0 DC 1m
Rh17_0 n17_0 n17_1 0.12591
Rv11_1 n11_1 n12_1 0.014368
Rh8_6 n8_6 n8_7 0.13124
Rh2_14 n2_14 n2_15 18.138
Rv16_9 n16_9 n17_9 1.1306
Rv10_6 n10_6 n11_6 53.962
Rv6_10 n6_10 n7_10 25.683
Rh6_0 n6_0 n6_1 0.29369
Rv4_11 n4_11 n5_11 0.013996
Rh10_5 n10_5 n10_6 20.317
Rh5_8 n5_8 n5_9 0.32792
Rv2_3 n2_3 n3_3 0.019842
Rv10_9 n10_9 n11_9 1.2791
Rh11_1 n11_1 n11_2 0.081394
Rpad2 vdd n17_0 0.01
Rh15_8 n15_8 n15_9 9.9229
Rv14_2 n14_2 n15_2 28.547
Rv3_14 n3_14 n4_14 0.18604
Rh6_15 n6_15 n6_16 0.066889
Rv4_14 n4_14 n5_14 0.037352
Rh5_1 n5_1 n5_2 0.2481
Rh14_0 n14_0 n14_1 6.6691
Rh10_0 n10_0 n10_1 0.012839
Rh16_0 n16_0 n16_1 0.013238
Rv9_10 n9_10 n10_10 0.034593
Rv5_4 n5_4 n6_4 0.83837
Rv2_1 n2_1 n3_1 14.951
Rv1_15 n1_15 n2_15 0.1804
Rh9_3 n9_3 n9_4 33
Rh11_8 n11_8 n11_9 0.016547
Rv16_14 n16_14 n17_14 0.013061
Rv2_7 n2_7 n3_7 40.71
Rv15_6 n15_6 n16_6 0.98646
Rv10_3 n10_3 n11_3 77.43
Rv3_0 n3_0 n4_0 0.017938
Rv12_2 n12_2 n13_2 14.72
Rv7_7 n7_7 n8_7 0.010263
Rv2_17 n2_17 n3_17 19.406
Rh9_14 n9_14 n9_15 0.44891
Rv12_5 n12_5 n13_5 36.524
Rh3_2 n3_2 n3_3 4.1829
Rh16_13 n16_13 n16_14 1.4649
Rh1_11 n1_11 n1_12 0.017859
Rh14_16 n14_16 n14_17 13.068
Rh17_7 n17_7 n17_8 0.10362
Rh4_5 n4_5 n4_6 5.54
Rv3_4 n3_4 n4_4 0.062824
Rh12_1 n12_1 n12_2 0.38123
Rh17_2 n17_2 n17_3 0.010787
Rh9_8 n9_8 n9_9 12.189
Rv5_3 n5_3 n6_3 42.61
Rv10_0 n10_0 n11_0 0.033085
Rv7_0 n7_0 n8_0 0.075662
Rv4_8 n4_8 n5_8 1.25
Rh11_14 n11_14 n11_15 0.12313
Rv12_0 n12_0 n13_0 1.8844
Rh10_11 n10_11 n10_12 59.25
Rv0_16 n0_16 n1_16 0.27045
Rh5_4 n5_4 n5_5 1.6258
Rh12_16 n12_16 n12_17 8.2478
Rh5_12 n5_12 n5_13 0.23783
Rh10_16 n10_16 n10_17 0.23083
Rh11_10 n11_10 n11_11 0.46305
Rv3_12 n3_12 n4_12 1.8951
Rv8_17 n8_17 n9_17 0.024716
Rh16_8 n16_8 n16_9 13.38
Rh1_3 n1_3 n1_4 30.856
Rv4_1 n4_1 n5_1 10.521
Rh7_0 n7_0 n7_1 0.037996
Rv11_15 n11_15 n12_15 0.090877
Rh15_11 n15_11 n15_12 0.37472
Rv15_12 n15_12 n16_12 0.010518
Rv4_3 n4_3 n5_3 80.83
Rv14_3 n14_3 n15_3 0.027858
Rv11_4 n11_4 n12_4 0.48514
Rv2_5 n2_5 n3_5 0.14593
Rv9_11 n9_11 n10_11 0.044524
Rh8_1 n8_1 n8_2 1.1833
Rv9_5 n9_5 n10_5 0.36996
Rh3_0 n3_0 n3_1 22.265
Rv3_6 n3_6 n4_6 0.013376
Rv16_0 n16_0 n17_0 59.91
Rh0_1 n0_1 n0_2 77.335
Rv15_1 n15_1 n16_1 64.016
Rv6_3 n6_3 n7_3 1.8471
Rv9_3 n9_3 n10_3 72.008
Rh8_7 n8_7 n8_8 0.66274
Rh13_7 n13_7 n13_8 0.065775
Rv7_9 n7_9 n8_9 3.726
Rh17_12 n17_12 n17_13 0.23309
Rh9_0 n9_0 n9_1 2.1589
Rv4_10 n4_10 n5_10 0.02524
Rv9_16 n9_16 n10_16 0.030178
Rv4_2 n4_2 n5_2 0.39399
Rv13_14 n13_14 n14_14 1.5096
Rv1_0 n1_0 n2_0 0.010267
Rv6_4 n6_4 n7_4 48.121
Rv0_8 n0_8 n1_8 33.62
Rv12_13 n12_13 n13_13 22.144
Rh1_14 n1_14 n1_15 0.036886
Rh6_6 n6_6 n6_7 1.2048
Rh9_12 n9_12 n9_13 25.651
Rv6_1 n6_1 n7_1 0.013614
Rh9_11 n9_11 n9_12 0.22494
Rh17_10 n17_10 n17_11 1.8988
Rv1_16 n1_16 n2_16 0.1643
Rh0_10 n0_10 n0_11 42.578
Rv0_1 n0_1 n1_1 0.45832
Rh0_2 n0_2 n0_3 60.187
Rh13_12 n13_12 n13_13 63.941
Rh15_14 n15_14 n15_15 6.6038
Rh0_3 n0_3 n0_4 3.0652
Rh15_9 n15_9 n15_10 1.0661
Rv1_13 n1_13 n2_13 22.579
Rh14_4 n14_4 n14_5 0.30545
Rv10_1 n10_1 n11_1 0.21482
Rv15_7 n15_7 n16_7 0.33937
Rh12_3 n12_3 n12_4 18.54
Rv8_11 n8_11 n9_11 4.7523
Rv10_16 n10_16 n11_16 0.36848
Rh13_14 n13_14 n13_15 3.1985
Rh17_1 n17_1 n17_2 95.963
Rv1_1 n1_1 n2_1 0.25022
Rh12_2 n12_2 n12_3 0.072442
Rv16_6 n16_6 n17_6 0.014279
Rpad1 vdd n0_17 0.01
Rv6_8 n6_8 n7_8 55.849
Rv16_11 n16_11 n17_11 23.172
Rv9_7 n9_7 n10_7 0.036538
Rh9_16 n9_16 n9_17 6.0891
Rh4_8 n4_8 n4_9 3.1022
Rv12_11 n12_11 n13_11 58.591
Rh12_15 n12_15 n12_16 36.738
Rv2_9 n2_9 n3_9 1.1089
Rv0_2 n0_2 n1_2 0.52223
Rh16_16 n16_16 n16_17 0.011605
I8 n15_15 0 DC 1m
Rh2_4 n2_4 n2_5 4.9655
Rh0_15 n0_15 n0_16 88.539
Rh14_15 n14_15 n14_16 0.046355
Rh1_4 n1_4 n1_5 8.7454
Rh0_6 n0_6 n0_7 0.57259
Rh10_6 n10_6 n10_7 0.80452
Rv16_7 n16_7 n17_7 36.705
Rh8_8 n8_8 n8_9 0.14688
Rv7_2 n7_2 n8_2 3.5682
Rh12_8 n12_8 n12_9 2.4269
Rv0_10 n0_10 n1_10 8.5895
Rv16_1 n16_1 n17_1 92.754
Rv6_11 n6_11 n7_11 0.20867
Rh1_0 n1_0 n1_1 17.129
Rv11_16 n11_16 n12_16 1.3555
Rv3_1 n3_1 n4_1 2.494
Rh6_8 n6_8 n6_9 0.12268
Rh8_3 n8_3 n8_4 0.52026
Rv12_16 n12_16 n13_16 0.17027
Rv4_12 n4_12 n5_12 0.042426
Rh4_13 n4_13 n4_14 0.23642
Rv15_11 n15_11 n16_11 0.6911
Rh16_1 n16_1 n16_2 0.073179
Rv15_4 n15_4 n16_4 0.22318
.op
.end
