Diode-resistor mesh 24x24 (722 unknowns, 144 diode-resistor legs), random numbering: nonlinear solve on the large-matrix solver tier
* bench.id: acc_dc_diode_resistor_mesh_24x24
* bench.group: accuracy
* bench.title: Diode-resistor mesh 24x24 (722 unknowns, 144 diode-resistor legs), random numbering: nonlinear solve on the large-matrix solver tier
* bench.probes: v(n23_23), v(n12_12), v(n0_0), i(v1)
* bench.oracle: dc_nonlinear(gmin=1e-12)
* bench.size: 722
* bench.tags: nonlinear, op, diode, mesh, random_numbering, large_matrix
* bench.note: default tolerances; RS reaches 1.7e-12 V, tight ngspice 4e-14 V versus an independent dense f64 Newton solve
Rv5_20 n5_20 n6_20 32.12
D0_4 n0_4 g0_4 dm
Rh16_21 n16_21 n16_22 716.5
Rv7_12 n7_12 n8_12 480.2
Rg10_10 g10_10 0 309.3
Rh23_4 n23_4 n23_5 64.61
Rh9_3 n9_3 n9_4 271.8
Rh5_6 n5_6 n5_7 28.02
Rg11_21 g11_21 0 5748
Rg0_12 g0_12 0 558.4
Rh18_15 n18_15 n18_16 139.3
Rv4_2 n4_2 n5_2 223
Rh16_9 n16_9 n16_10 20.61
Rh9_8 n9_8 n9_9 669.5
Rv2_17 n2_17 n3_17 177.7
Rv19_22 n19_22 n20_22 91.11
Rv12_4 n12_4 n13_4 63.66
Rh3_11 n3_11 n3_12 198.2
Rv3_21 n3_21 n4_21 138.2
Rv12_3 n12_3 n13_3 780.3
Rv16_16 n16_16 n17_16 112.8
Rv5_19 n5_19 n6_19 658.3
Rh22_5 n22_5 n22_6 10.2
Rh16_3 n16_3 n16_4 147.3
Rh16_15 n16_15 n16_16 44.73
Rv17_1 n17_1 n18_1 141.6
Rh12_0 n12_0 n12_1 104.8
Rh16_11 n16_11 n16_12 49.06
Rh4_13 n4_13 n4_14 581.8
Rh18_2 n18_2 n18_3 282.9
D19_9 n19_9 g19_9 dm
Rh16_14 n16_14 n16_15 39.5
Rv8_14 n8_14 n9_14 13.9
D20_8 n20_8 g20_8 dm
Rh22_9 n22_9 n22_10 48.1
Rv11_19 n11_19 n12_19 260.6
Rh12_16 n12_16 n12_17 541.3
Rh4_1 n4_1 n4_2 57.01
Rh1_2 n1_2 n1_3 149.7
Rh18_9 n18_9 n18_10 503.8
D2_10 n2_10 g2_10 dm
Rh17_17 n17_17 n17_18 193.4
Rh4_11 n4_11 n4_12 223.3
Rv15_23 n15_23 n16_23 70.74
Rv8_18 n8_18 n9_18 498.9
Rv21_20 n21_20 n22_20 42.73
Rh7_21 n7_21 n7_22 47.57
Rv2_12 n2_12 n3_12 429.4
Rh22_14 n22_14 n22_15 14.28
Rv5_11 n5_11 n6_11 219.2
Rh17_1 n17_1 n17_2 111.5
D17_11 n17_11 g17_11 dm
Rv4_3 n4_3 n5_3 24.45
Rh18_18 n18_18 n18_19 65.55
Rh20_10 n20_10 n20_11 519.6
Rv5_15 n5_15 n6_15 17.03
Rh19_1 n19_1 n19_2 54.54
Rg19_1 g19_1 0 7137
Rv22_10 n22_10 n23_10 11.12
Rh0_8 n0_8 n0_9 28.68
Rh3_19 n3_19 n3_20 10.4
Rg5_3 g5_3 0 3970
Rv1_0 n1_0 n2_0 457.2
Rv15_9 n15_9 n16_9 12.75
D6_10 n6_10 g6_10 dm
Rv21_1 n21_1 n22_1 710.6
Rv15_20 n15_20 n16_20 18.2
Rg1_11 g1_11 0 2795
Rv10_13 n10_13 n11_13 100.2
Rv21_6 n21_6 n22_6 66.57
Rh17_6 n17_6 n17_7 84.95
Rv21_14 n21_14 n22_14 47.51
D11_21 n11_21 g11_21 dm
Rv0_7 n0_7 n1_7 277.4
Rh11_13 n11_13 n11_14 198.4
Rh9_17 n9_17 n9_18 17.31
D4_0 n4_0 g4_0 dm
Rh17_9 n17_9 n17_10 133.5
Rh2_18 n2_18 n2_19 48.85
Rv12_6 n12_6 n13_6 26.03
Rh15_19 n15_19 n15_20 58.68
Rh4_14 n4_14 n4_15 93.11
Rh7_12 n7_12 n7_13 652.1
Rv18_18 n18_18 n19_18 181.9
Rv14_1 n14_1 n15_1 12.37
Rv1_16 n1_16 n2_16 347.6
Rv11_15 n11_15 n12_15 748.6
Rg12_4 g12_4 0 2066
Rv3_12 n3_12 n4_12 43.9
Rv12_18 n12_18 n13_18 487.1
Rh8_16 n8_16 n8_17 20.84
Rh5_12 n5_12 n5_13 15.25
Rh12_6 n12_6 n12_7 26.17
Rh6_19 n6_19 n6_20 30.92
D14_6 n14_6 g14_6 dm
Rh3_22 n3_22 n3_23 22.03
Rh21_9 n21_9 n21_10 832
Rg5_7 g5_7 0 1612
Rv7_5 n7_5 n8_5 439.6
Rv3_1 n3_1 n4_1 16.5
Rh3_6 n3_6 n3_7 273.9
Rv9_19 n9_19 n10_19 31.36
Rv15_14 n15_14 n16_14 61.71
Rh3_21 n3_21 n3_22 840.2
Rv13_7 n13_7 n14_7 273.5
Rv10_14 n10_14 n11_14 41.93
Rh10_15 n10_15 n10_16 101.4
Rv13_8 n13_8 n14_8 16.32
Rh11_22 n11_22 n11_23 93.13
Rh23_0 n23_0 n23_1 191.6
Rv14_14 n14_14 n15_14 17.17
D21_19 n21_19 g21_19 dm
Rv7_1 n7_1 n8_1 20.34
Rh22_10 n22_10 n22_11 108.9
Rh2_12 n2_12 n2_13 392.8
Rh12_15 n12_15 n12_16 22.12
Rh21_11 n21_11 n21_12 67.24
Rh15_14 n15_14 n15_15 18.05
Rv0_23 n0_23 n1_23 746.2
Rv15_3 n15_3 n16_3 70.51
Rv13_23 n13_23 n14_23 45.73
Rh4_21 n4_21 n4_22 543
Rh13_7 n13_7 n13_8 273.1
Rh14_7 n14_7 n14_8 672
Rh18_10 n18_10 n18_11 23.96
Rh10_11 n10_11 n10_12 123.2
Rh11_17 n11_17 n11_18 342.8
Rh12_22 n12_22 n12_23 372.2
Rh10_21 n10_21 n10_22 56.9
Rv4_17 n4_17 n5_17 26.66
Rv11_23 n11_23 n12_23 12.32
Rh20_19 n20_19 n20_20 964.1
Rh2_14 n2_14 n2_15 221.9
D18_14 n18_14 g18_14 dm
Rg18_10 g18_10 0 244.1
Rh10_20 n10_20 n10_21 96.52
Rh6_17 n6_17 n6_18 46.63
Rh15_8 n15_8 n15_9 687.5
Rh13_3 n13_3 n13_4 33.42
D1_11 n1_11 g1_11 dm
Rv18_22 n18_22 n19_22 187.6
Rh6_3 n6_3 n6_4 671.1
Rv0_3 n0_3 n1_3 378
Rg14_10 g14_10 0 2219
Rv5_2 n5_2 n6_2 376.9
Rv21_13 n21_13 n22_13 54.37
Rg9_15 g9_15 0 9274
D13_19 n13_19 g13_19 dm
Rv10_2 n10_2 n11_2 148.4
Rh10_22 n10_22 n10_23 10.18
Rv3_13 n3_13 n4_13 13.11
Rg21_3 g21_3 0 204.7
Rv9_12 n9_12 n10_12 875.8
Rv1_2 n1_2 n2_2 582
Rv6_18 n6_18 n7_18 155.6
V1 vdd 0 5
Rv19_19 n19_19 n20_19 15.23
Rv9_21 n9_21 n10_21 75.43
Rg8_0 g8_0 0 118.8
Rh7_4 n7_4 n7_5 22.21
Rh1_9 n1_9 n1_10 75.5
Rg7_21 g7_21 0 874
Rg12_0 g12_0 0 492.6
Rv22_17 n22_17 n23_17 18.97
D22_6 n22_6 g22_6 dm
Rv13_15 n13_15 n14_15 48.4
Rh17_18 n17_18 n17_19 529.3
Rv17_4 n17_4 n18_4 766.7
Rg16_12 g16_12 0 2711
Rv15_17 n15_17 n16_17 398.8
Rg13_11 g13_11 0 4288
D17_15 n17_15 g17_15 dm
Rh0_9 n0_9 n0_10 635.1
Rin vdd n0_0 100
Rh9_6 n9_6 n9_7 917.2
Rv9_9 n9_9 n10_9 356.1
Rv22_2 n22_2 n23_2 28.35
Rg11_5 g11_5 0 207.6
Rv5_22 n5_22 n6_22 12
Rh14_18 n14_18 n14_19 211.9
Rh5_16 n5_16 n5_17 21.62
Rh15_16 n15_16 n15_17 11.2
Rh16_1 n16_1 n16_2 45.73
Rh10_0 n10_0 n10_1 468.5
D3_1 n3_1 g3_1 dm
D14_10 n14_10 g14_10 dm
Rv7_13 n7_13 n8_13 239.4
Rv14_8 n14_8 n15_8 213.6
Rv17_11 n17_11 n18_11 12.6
Rh20_7 n20_7 n20_8 220.4
D21_15 n21_15 g21_15 dm
D8_16 n8_16 g8_16 dm
Rg18_22 g18_22 0 1389
Rv21_16 n21_16 n22_16 244.5
Rg14_14 g14_14 0 6064
Rv13_0 n13_0 n14_0 883.3
D1_15 n1_15 g1_15 dm
Rv9_10 n9_10 n10_10 208.7
Rv7_15 n7_15 n8_15 268.9
Rh13_12 n13_12 n13_13 599.4
Rv0_13 n0_13 n1_13 27.76
Rh14_22 n14_22 n14_23 151.7
Rv20_1 n20_1 n21_1 15.08
D4_20 n4_20 g4_20 dm
Rh2_11 n2_11 n2_12 527.3
Rv9_20 n9_20 n10_20 10.19
Rv8_8 n8_8 n9_8 290.3
Rh6_0 n6_0 n6_1 922.9
Rh4_20 n4_20 n4_21 47.93
Rv13_12 n13_12 n14_12 27.11
Rh4_15 n4_15 n4_16 29.46
Rh5_19 n5_19 n5_20 872
Rh19_3 n19_3 n19_4 218.5
Rg11_9 g11_9 0 3579
D21_23 n21_23 g21_23 dm
Rv19_17 n19_17 n20_17 269.7
Rh9_0 n9_0 n9_1 31.71
Rh9_19 n9_19 n9_20 38.99
D5_3 n5_3 g5_3 dm
Rv12_10 n12_10 n13_10 297.5
Rh17_4 n17_4 n17_5 52.86
Rv9_0 n9_0 n10_0 27.24
Rh12_3 n12_3 n12_4 103.4
Rv15_15 n15_15 n16_15 581.6
Rh8_14 n8_14 n8_15 12.49
Rh18_22 n18_22 n18_23 21.18
Rv20_18 n20_18 n21_18 596.9
Rh5_5 n5_5 n5_6 57.03
Rh7_6 n7_6 n7_7 43.61
Rh20_20 n20_20 n20_21 96.59
Rv11_16 n11_16 n12_16 492.6
Rh2_6 n2_6 n2_7 51.71
Rh7_1 n7_1 n7_2 531.2
Rv16_21 n16_21 n17_21 870
D8_12 n8_12 g8_12 dm
Rv16_19 n16_19 n17_19 909.5
Rv19_14 n19_14 n20_14 106.6
Rv18_2 n18_2 n19_2 424.7
Rh11_6 n11_6 n11_7 115.3
Rh5_8 n5_8 n5_9 134.6
Rh2_4 n2_4 n2_5 138
Rh14_15 n14_15 n14_16 15.21
Rg0_0 g0_0 0 884
Rv11_3 n11_3 n12_3 308.5
Rv13_19 n13_19 n14_19 21.74
Rh11_2 n11_2 n11_3 83.78
Rh17_20 n17_20 n17_21 263.4
Rh15_13 n15_13 n15_14 115.6
Rv16_8 n16_8 n17_8 38.25
Rv8_12 n8_12 n9_12 684.6
Rv14_15 n14_15 n15_15 11.36
Rg3_17 g3_17 0 208.7
D23_9 n23_9 g23_9 dm
Rv2_5 n2_5 n3_5 93.29
Rh15_21 n15_21 n15_22 388.3
Rv22_1 n22_1 n23_1 133.7
Rv5_12 n5_12 n6_12 16.99
Rh4_5 n4_5 n4_6 39.1
Rg2_22 g2_22 0 270.7
Rh14_0 n14_0 n14_1 153.9
Rv10_11 n10_11 n11_11 850.9
Rv13_14 n13_14 n14_14 847.7
Rv2_23 n2_23 n3_23 11.15
Rh23_7 n23_7 n23_8 113.6
Rv17_9 n17_9 n18_9 651
Rv21_23 n21_23 n22_23 32.58
Rg20_8 g20_8 0 3405
Rv17_22 n17_22 n18_22 610.4
Rh14_5 n14_5 n14_6 63.07
Rv2_4 n2_4 n3_4 25.1
Rv15_0 n15_0 n16_0 110.7
Rh3_16 n3_16 n3_17 521.2
Rh19_8 n19_8 n19_9 47.11
Rv0_12 n0_12 n1_12 69.86
Rv7_10 n7_10 n8_10 42.87
Rh6_10 n6_10 n6_11 14.55
Rh20_11 n20_11 n20_12 225.7
Rh6_21 n6_21 n6_22 126.6
Rv13_11 n13_11 n14_11 156.7
Rh0_16 n0_16 n0_17 27.39
Rv12_12 n12_12 n13_12 426.6
Rh15_1 n15_1 n15_2 13.23
Rv16_15 n16_15 n17_15 314.1
Rv1_11 n1_11 n2_11 95.36
Rh13_6 n13_6 n13_7 318.2
D23_1 n23_1 g23_1 dm
Rv22_14 n22_14 n23_14 281.7
Rv19_8 n19_8 n20_8 81.71
Rv4_0 n4_0 n5_0 104.2
Rv5_14 n5_14 n6_14 946.9
Rh16_12 n16_12 n16_13 12.22
Rv12_19 n12_19 n13_19 629.2
Rv16_18 n16_18 n17_18 45.2
Rh21_1 n21_1 n21_2 206.3
Rh9_18 n9_18 n9_19 65.53
Rv20_23 n20_23 n21_23 93.75
Rv10_23 n10_23 n11_23 157.2
Rv14_5 n14_5 n15_5 575.5
Rh9_5 n9_5 n9_6 288.3
D13_3 n13_3 g13_3 dm
Rv17_8 n17_8 n18_8 236.9
Rg4_16 g4_16 0 346.3
Rh15_10 n15_10 n15_11 15.22
Rh8_9 n8_9 n8_10 29.97
Rv3_3 n3_3 n4_3 162.7
Rh10_4 n10_4 n10_5 382.1
Rg3_5 g3_5 0 4971
Rh9_15 n9_15 n9_16 44.76
Rv16_20 n16_20 n17_20 669.5
Rv11_9 n11_9 n12_9 147.5
Rv6_5 n6_5 n7_5 172
Rv10_17 n10_17 n11_17 79.27
Rg2_18 g2_18 0 5731
Rg22_14 g22_14 0 1190
Rh23_13 n23_13 n23_14 125.4
Rh22_4 n22_4 n22_5 586.9
Rh12_21 n12_21 n12_22 73.04
Rv22_4 n22_4 n23_4 69.91
D5_11 n5_11 g5_11 dm
Rh20_3 n20_3 n20_4 125.7
Rv18_17 n18_17 n19_17 806.7
Rh10_13 n10_13 n10_14 18.76
Rv14_0 n14_0 n15_0 659.1
Rh19_19 n19_19 n19_20 270.6
Rv9_7 n9_7 n10_7 34.28
Rg3_13 g3_13 0 5987
Rh23_15 n23_15 n23_16 104
Rh19_16 n19_16 n19_17 73.62
Rh18_7 n18_7 n18_8 582.6
Rv1_8 n1_8 n2_8 56.16
Rv9_15 n9_15 n10_15 17.89
Rh5_11 n5_11 n5_12 10.59
Rh4_16 n4_16 n4_17 14.77
D22_2 n22_2 g22_2 dm
Rh6_18 n6_18 n6_19 143.9
Rg8_8 g8_8 0 100.3
Rv15_6 n15_6 n16_6 31.85
Rv2_19 n2_19 n3_19 113.4
Rh21_3 n21_3 n21_4 120.5
D11_17 n11_17 g11_17 dm
Rv5_1 n5_1 n6_1 14.01
D2_14 n2_14 g2_14 dm
Rh19_14 n19_14 n19_15 32.8
D11_9 n11_9 g11_9 dm
D19_5 n19_5 g19_5 dm
D16_4 n16_4 g16_4 dm
Rg21_23 g21_23 0 621
Rv10_1 n10_1 n11_1 121.5
Rv6_20 n6_20 n7_20 13.95
Rv7_11 n7_11 n8_11 405.2
Rg14_22 g14_22 0 1930
D0_0 n0_0 g0_0 dm
Rh3_7 n3_7 n3_8 256.6
Rh13_19 n13_19 n13_20 56.99
Rh18_11 n18_11 n18_12 241.4
D20_20 n20_20 g20_20 dm
Rh15_9 n15_9 n15_10 506.2
D19_13 n19_13 g19_13 dm
D15_9 n15_9 g15_9 dm
Rh18_0 n18_0 n18_1 224.5
Rv22_11 n22_11 n23_11 19.01
Rh21_16 n21_16 n21_17 575.2
Rh14_20 n14_20 n14_21 192
Rv4_20 n4_20 n5_20 38.23
Rv21_17 n21_17 n22_17 13.07
Rv14_22 n14_22 n15_22 50.03
D12_12 n12_12 g12_12 dm
Rg17_7 g17_7 0 2057
Rv8_2 n8_2 n9_2 32.98
Rv5_13 n5_13 n6_13 12.02
Rv5_6 n5_6 n6_6 14.57
Rv11_17 n11_17 n12_17 427.2
Rh18_16 n18_16 n18_17 112.5
Rv21_4 n21_4 n22_4 483.9
Rh7_19 n7_19 n7_20 121
D9_19 n9_19 g9_19 dm
Rh22_3 n22_3 n22_4 25.05
Rv16_2 n16_2 n17_2 817.7
Rh20_15 n20_15 n20_16 510.2
Rh8_21 n8_21 n8_22 515.9
Rh1_8 n1_8 n1_9 223.3
Rh13_13 n13_13 n13_14 11.73
Rh0_0 n0_0 n0_1 18.57
D23_5 n23_5 g23_5 dm
Rh17_15 n17_15 n17_16 112.9
D6_2 n6_2 g6_2 dm
D0_8 n0_8 g0_8 dm
Rh21_21 n21_21 n21_22 97.15
Rv4_13 n4_13 n5_13 236.7
Rv2_7 n2_7 n3_7 176.6
Rh12_12 n12_12 n12_13 267.2
Rh15_4 n15_4 n15_5 211.2
D2_18 n2_18 g2_18 dm
Rh15_0 n15_0 n15_1 132
Rh12_20 n12_20 n12_21 175.8
Rv17_16 n17_16 n18_16 502.6
Rh9_20 n9_20 n9_21 315.6
D15_1 n15_1 g15_1 dm
Rg14_2 g14_2 0 1091
Rh0_10 n0_10 n0_11 11.24
Rh1_20 n1_20 n1_21 82.84
Rh6_1 n6_1 n6_2 156
Rv22_16 n22_16 n23_16 12.58
Rh2_2 n2_2 n2_3 132.7
Rh15_6 n15_6 n15_7 319.5
Rh17_12 n17_12 n17_13 15.79
Rv0_6 n0_6 n1_6 10.1
Rg20_16 g20_16 0 3942
Rh3_1 n3_1 n3_2 23.77
Rh1_6 n1_6 n1_7 67.4
Rh20_12 n20_12 n20_13 60.18
Rh9_7 n9_7 n9_8 180.7
Rh19_15 n19_15 n19_16 301.3
D0_20 n0_20 g0_20 dm
Rv17_0 n17_0 n18_0 18.58
Rh20_1 n20_1 n20_2 466.4
Rh10_17 n10_17 n10_18 76.67
D16_0 n16_0 g16_0 dm
Rh19_9 n19_9 n19_10 17.1
Rv3_2 n3_2 n4_2 104.8
Rv19_20 n19_20 n20_20 857.1
Rv3_0 n3_0 n4_0 69.48
Rv4_19 n4_19 n5_19 54.48
Rv19_1 n19_1 n20_1 63.72
Rg16_4 g16_4 0 4653
Rv11_1 n11_1 n12_1 942
Rh17_5 n17_5 n17_6 193.6
Rv11_20 n11_20 n12_20 122.6
Rg2_14 g2_14 0 192.2
Rh11_9 n11_9 n11_10 527.8
Rv16_23 n16_23 n17_23 699.2
D13_23 n13_23 g13_23 dm
Rh4_17 n4_17 n4_18 663.7
Rv0_19 n0_19 n1_19 23.54
Rv4_12 n4_12 n5_12 48.72
Rh2_15 n2_15 n2_16 10.8
Rv18_0 n18_0 n19_0 122.7
Rg2_2 g2_2 0 2316
Rh23_1 n23_1 n23_2 486
Rv0_11 n0_11 n1_11 57.86
Rh8_13 n8_13 n8_14 35.52
Rg13_7 g13_7 0 387.1
Rg23_5 g23_5 0 9211
Rh17_22 n17_22 n17_23 538.3
Rh11_16 n11_16 n11_17 367.2
Rv20_17 n20_17 n21_17 110
D7_13 n7_13 g7_13 dm
Rh13_22 n13_22 n13_23 26.53
Rg0_20 g0_20 0 1226
Rh0_13 n0_13 n0_14 11.43
Rh0_3 n0_3 n0_4 201
Rv22_15 n22_15 n23_15 43.06
Rv1_5 n1_5 n2_5 393.4
Rv6_1 n6_1 n7_1 79.38
Rv13_20 n13_20 n14_20 436.8
Rv20_0 n20_0 n21_0 279.9
Rv21_0 n21_0 n22_0 950.5
Rh7_17 n7_17 n7_18 13.45
Rv5_23 n5_23 n6_23 10.5
Rh21_14 n21_14 n21_15 87.32
Rv10_8 n10_8 n11_8 36.99
Rv10_3 n10_3 n11_3 232.8
Rh1_22 n1_22 n1_23 10.27
Rh21_17 n21_17 n21_18 117.4
Rv16_4 n16_4 n17_4 78.93
Rg2_10 g2_10 0 6713
Rh11_5 n11_5 n11_6 21.91
Rv22_6 n22_6 n23_6 170.1
Rv16_10 n16_10 n17_10 15.66
Rh13_0 n13_0 n13_1 21.44
Rg19_9 g19_9 0 199.4
Rv3_18 n3_18 n4_18 31.97
Rh17_14 n17_14 n17_15 33.37
Rh12_9 n12_9 n12_10 111.3
Rh5_20 n5_20 n5_21 38.73
Rh8_10 n8_10 n8_11 90.71
Rv7_17 n7_17 n8_17 844.8
Rh13_16 n13_16 n13_17 474
Rg11_1 g11_1 0 519.3
Rv13_13 n13_13 n14_13 255.8
Rv20_21 n20_21 n21_21 26.87
Rh4_19 n4_19 n4_20 481.1
Rv13_9 n13_9 n14_9 96.54
Rv4_18 n4_18 n5_18 158.6
Rv7_6 n7_6 n8_6 16.36
Rv21_7 n21_7 n22_7 24.58
Rv2_15 n2_15 n3_15 10.69
Rh20_18 n20_18 n20_19 68.11
Rv8_21 n8_21 n9_21 621.2
D5_23 n5_23 g5_23 dm
Rv5_5 n5_5 n6_5 138.5
Rv2_9 n2_9 n3_9 28.79
Rh3_13 n3_13 n3_14 182.8
Rh13_10 n13_10 n13_11 15.85
Rh1_14 n1_14 n1_15 153.6
Rv22_7 n22_7 n23_7 28.12
Rh2_5 n2_5 n2_6 102.2
Rv3_22 n3_22 n4_22 544
Rv11_12 n11_12 n12_12 190.9
Rv14_16 n14_16 n15_16 308.5
Rv12_22 n12_22 n13_22 23.98
Rv9_11 n9_11 n10_11 77.65
Rh15_20 n15_20 n15_21 42.31
Rh20_22 n20_22 n20_23 330.6
Rh8_5 n8_5 n8_6 29.31
D6_14 n6_14 g6_14 dm
Rv19_9 n19_9 n20_9 51.17
Rh3_8 n3_8 n3_9 122.9
Rh1_7 n1_7 n1_8 125.2
Rv21_12 n21_12 n22_12 34.21
Rv21_8 n21_8 n22_8 157.4
Rh3_10 n3_10 n3_11 107.9
Rh2_13 n2_13 n2_14 32.4
Rv8_3 n8_3 n9_3 62.46
D7_21 n7_21 g7_21 dm
Rv4_6 n4_6 n5_6 553.7
Rv20_19 n20_19 n21_19 37.77
D7_9 n7_9 g7_9 dm
D10_18 n10_18 g10_18 dm
Rv21_15 n21_15 n22_15 23.04
Rv14_20 n14_20 n15_20 30.63
Rv9_14 n9_14 n10_14 21.36
Rh8_22 n8_22 n8_23 832.1
Rh11_0 n11_0 n11_1 579.9
Rv6_21 n6_21 n7_21 13.86
Rv3_20 n3_20 n4_20 435.3
Rv12_2 n12_2 n13_2 10.95
Rv12_16 n12_16 n13_16 45.63
Rv15_10 n15_10 n16_10 422.8
D23_21 n23_21 g23_21 dm
Rg10_18 g10_18 0 301.7
Rh20_9 n20_9 n20_10 91.08
D10_2 n10_2 g10_2 dm
Rv13_4 n13_4 n14_4 18.89
Rh10_1 n10_1 n10_2 37.12
Rv2_16 n2_16 n3_16 31.56
Rv9_4 n9_4 n10_4 21.36
Rv15_4 n15_4 n16_4 267.4
Rv5_17 n5_17 n6_17 16.06
Rv21_2 n21_2 n22_2 34.28
Rv7_18 n7_18 n8_18 125.5
Rv13_18 n13_18 n14_18 97.73
Rg7_13 g7_13 0 1628
Rg23_9 g23_9 0 6524
Rh2_7 n2_7 n2_8 119.4
Rg7_1 g7_1 0 699.1
Rh1_18 n1_18 n1_19 29.13
Rv16_11 n16_11 n17_11 141.2
Rv12_13 n12_13 n13_13 165.7
Rh1_13 n1_13 n1_14 255.1
Rh16_22 n16_22 n16_23 427.8
Rh1_4 n1_4 n1_5 150.7
Rh7_16 n7_16 n7_17 216.5
Rh8_2 n8_2 n8_3 17.79
D18_2 n18_2 g18_2 dm
Rv13_22 n13_22 n14_22 269.1
Rh16_2 n16_2 n16_3 369.2
Rh23_9 n23_9 n23_10 117.9
Rv15_11 n15_11 n16_11 55.02
Rh22_16 n22_16 n22_17 34.57
D18_10 n18_10 g18_10 dm
D10_6 n10_6 g10_6 dm
Rh1_10 n1_10 n1_11 360.5
Rh23_6 n23_6 n23_7 174.3
Rg14_18 g14_18 0 221
Rh6_9 n6_9 n6_10 41.18
Rg19_17 g19_17 0 165.2
Rv4_7 n4_7 n5_7 10.87
Rv5_0 n5_0 n6_0 16.16
Rv20_7 n20_7 n21_7 17.27
Rv8_22 n8_22 n9_22 138.8
Rv18_8 n18_8 n19_8 12.03
Rv5_21 n5_21 n6_21 15.86
Rv7_4 n7_4 n8_4 356.8
D17_3 n17_3 g17_3 dm
D1_19 n1_19 g1_19 dm
Rh0_7 n0_7 n0_8 77.76
Rv1_23 n1_23 n2_23 437.5
Rh10_6 n10_6 n10_7 95.86
Rv3_10 n3_10 n4_10 27.95
Rv19_11 n19_11 n20_11 33.15
Rv13_10 n13_10 n14_10 23.63
Rv14_18 n14_18 n15_18 60.17
D7_1 n7_1 g7_1 dm
Rv12_15 n12_15 n13_15 379.8
Rv17_7 n17_7 n18_7 21.66
Rh8_11 n8_11 n8_12 66.76
Rh14_8 n14_8 n14_9 19.51
D4_8 n4_8 g4_8 dm
Rh10_7 n10_7 n10_8 345.3
Rv9_2 n9_2 n10_2 230.8
Rh13_14 n13_14 n13_15 426.4
Rv10_6 n10_6 n11_6 514.5
Rh19_20 n19_20 n19_21 18.15
Rh12_11 n12_11 n12_12 21.73
Rv19_13 n19_13 n20_13 989.6
Rv2_21 n2_21 n3_21 81.17
Rh12_13 n12_13 n12_14 34.64
Rh7_11 n7_11 n7_12 640
Rv15_7 n15_7 n16_7 20.05
D9_23 n9_23 g9_23 dm
Rv11_0 n11_0 n12_0 455.9
Rv19_15 n19_15 n20_15 241.3
Rh2_16 n2_16 n2_17 324.5
Rv18_6 n18_6 n19_6 64.19
Rg18_6 g18_6 0 2796
Rv6_15 n6_15 n7_15 494.6
Rh7_14 n7_14 n7_15 22.71
Rh6_14 n6_14 n6_15 41.07
Rv22_3 n22_3 n23_3 136.5
Rg2_6 g2_6 0 204.9
Rh8_8 n8_8 n8_9 236.1
D14_14 n14_14 g14_14 dm
Rg11_17 g11_17 0 424
Rg1_19 g1_19 0 115
Rg3_9 g3_9 0 468.7
Rh3_17 n3_17 n3_18 756.1
Rv11_7 n11_7 n12_7 60.02
Rh5_7 n5_7 n5_8 34.15
Rh15_5 n15_5 n15_6 306.6
D0_16 n0_16 g0_16 dm
Rh22_15 n22_15 n22_16 16.08
Rg6_18 g6_18 0 3618
Rh11_18 n11_18 n11_19 162.5
Rv9_13 n9_13 n10_13 403.1
Rv20_20 n20_20 n21_20 616.6
Rh11_15 n11_15 n11_16 185.1
Rh2_3 n2_3 n2_4 12.95
Rg3_21 g3_21 0 4991
Rh4_6 n4_6 n4_7 44.74
Rv17_14 n17_14 n18_14 183.8
Rh9_13 n9_13 n9_14 58.17
Rv16_14 n16_14 n17_14 50.73
D20_16 n20_16 g20_16 dm
Rv3_5 n3_5 n4_5 19.63
Rh14_14 n14_14 n14_15 35.25
Rv20_9 n20_9 n21_9 386
Rg9_7 g9_7 0 515.9
D2_6 n2_6 g2_6 dm
Rv18_23 n18_23 n19_23 975.1
Rv1_17 n1_17 n2_17 525.5
Rh9_9 n9_9 n9_10 18.98
Rv2_2 n2_2 n3_2 71.15
Rv1_4 n1_4 n2_4 11.72
D1_7 n1_7 g1_7 dm
Rh9_10 n9_10 n9_11 482.9
D20_0 n20_0 g20_0 dm
Rv13_16 n13_16 n14_16 17.22
D17_23 n17_23 g17_23 dm
Rh10_19 n10_19 n10_20 368.3
Rh20_5 n20_5 n20_6 869.4
Rv17_5 n17_5 n18_5 63.85
Rv10_15 n10_15 n11_15 51.72
Rh21_20 n21_20 n21_21 606.8
Rv22_18 n22_18 n23_18 736.9
Rg5_19 g5_19 0 6908
Rv22_12 n22_12 n23_12 346.7
Rg5_11 g5_11 0 103.8
Rh3_5 n3_5 n3_6 10.86
Rv15_16 n15_16 n16_16 111.9
Rv18_14 n18_14 n19_14 121.9
Rh23_12 n23_12 n23_13 184.3
Rh2_8 n2_8 n2_9 167.8
Rv8_5 n8_5 n9_5 10.35
Rv10_7 n10_7 n11_7 138.4
Rv7_16 n7_16 n8_16 32
Rv17_10 n17_10 n18_10 66.41
Rh9_16 n9_16 n9_17 657.3
Rg10_6 g10_6 0 4359
Rv6_17 n6_17 n7_17 122.6
Rv18_16 n18_16 n19_16 121.4
Rv18_13 n18_13 n19_13 311.7
Rv1_10 n1_10 n2_10 110.1
Rv11_21 n11_21 n12_21 463.4
Rv7_7 n7_7 n8_7 689.8
D2_22 n2_22 g2_22 dm
D6_6 n6_6 g6_6 dm
D16_8 n16_8 g16_8 dm
D21_3 n21_3 g21_3 dm
Rh19_2 n19_2 n19_3 746.5
Rv3_4 n3_4 n4_4 11.01
Rh0_1 n0_1 n0_2 336.9
Rv20_10 n20_10 n21_10 374
D19_17 n19_17 g19_17 dm
Rv17_17 n17_17 n18_17 22.22
Rh22_21 n22_21 n22_22 107.3
D4_4 n4_4 g4_4 dm
Rv4_11 n4_11 n5_11 473.6
Rv15_1 n15_1 n16_1 50.87
Rh13_17 n13_17 n13_18 242.8
Rv8_23 n8_23 n9_23 22.52
Rv7_8 n7_8 n8_8 613.1
Rh9_2 n9_2 n9_3 12.71
Rv3_7 n3_7 n4_7 227.2
Rv18_12 n18_12 n19_12 40.3
Rv8_11 n8_11 n9_11 132.1
Rg0_4 g0_4 0 640.6
Rh14_1 n14_1 n14_2 974.5
Rv6_3 n6_3 n7_3 870.2
Rh4_22 n4_22 n4_23 810.2
Rh14_10 n14_10 n14_11 18.2
Rh0_5 n0_5 n0_6 469.4
Rv5_4 n5_4 n6_4 366.3
D6_18 n6_18 g6_18 dm
Rh19_10 n19_10 n19_11 67.67
Rv15_18 n15_18 n16_18 11.71
Rg15_17 g15_17 0 110.5
Rv0_9 n0_9 n1_9 11.51
D22_22 n22_22 g22_22 dm
Rg17_19 g17_19 0 875.7
Rh6_13 n6_13 n6_14 761.1
Rh21_18 n21_18 n21_19 44.88
Rh15_15 n15_15 n15_16 260.2
Rh11_1 n11_1 n11_2 105.2
D3_17 n3_17 g3_17 dm
Rg6_6 g6_6 0 1330
Rv4_16 n4_16 n5_16 21.85
Rg16_16 g16_16 0 158.3
Rv10_21 n10_21 n11_21 25.58
D8_20 n8_20 g8_20 dm
Rh19_6 n19_6 n19_7 390.7
Rh8_6 n8_6 n8_7 114.1
Rg8_16 g8_16 0 166.8
D20_4 n20_4 g20_4 dm
Rv9_18 n9_18 n10_18 17.23
D15_5 n15_5 g15_5 dm
D8_4 n8_4 g8_4 dm
Rh8_20 n8_20 n8_21 297.1
Rh11_20 n11_20 n11_21 559.6
Rg23_21 g23_21 0 300.8
Rg4_12 g4_12 0 1592
Rg17_23 g17_23 0 966.6
Rv0_16 n0_16 n1_16 83.02
Rv8_6 n8_6 n9_6 100.4
Rh6_11 n6_11 n6_12 926.3
Rh8_4 n8_4 n8_5 63.41
Rh23_10 n23_10 n23_11 61.31
Rg23_17 g23_17 0 484.1
Rv6_16 n6_16 n7_16 40.33
Rv3_23 n3_23 n4_23 886.2
Rh19_4 n19_4 n19_5 708.5
Rh22_2 n22_2 n22_3 234.2
Rh19_18 n19_18 n19_19 96.11
Rh16_6 n16_6 n16_7 467.3
Rg12_16 g12_16 0 129.2
Rv8_0 n8_0 n9_0 13.32
Rg15_1 g15_1 0 943.8
Rv17_13 n17_13 n18_13 16.36
Rh14_3 n14_3 n14_4 43.57
Rv7_3 n7_3 n8_3 791.5
Rv4_5 n4_5 n5_5 99.91
Rh8_3 n8_3 n8_4 454.9
Rv13_21 n13_21 n14_21 144.5
Rv13_17 n13_17 n14_17 15.5
Rh13_4 n13_4 n13_5 18.93
Rv12_7 n12_7 n13_7 34.53
Rv16_12 n16_12 n17_12 426.5
Rv20_4 n20_4 n21_4 780.2
Rh2_19 n2_19 n2_20 20.86
Rh1_0 n1_0 n1_1 69.86
D8_8 n8_8 g8_8 dm
Rh0_22 n0_22 n0_23 277.3
D11_5 n11_5 g11_5 dm
Rh17_21 n17_21 n17_22 606.1
Rv20_12 n20_12 n21_12 217.5
Rh0_14 n0_14 n0_15 75.12
Rv14_19 n14_19 n15_19 869.3
Rv20_8 n20_8 n21_8 36.1
Rh0_15 n0_15 n0_16 29.25
Rv22_22 n22_22 n23_22 50.67
Rg0_16 g0_16 0 2036
Rv6_23 n6_23 n7_23 38.16
Rv10_5 n10_5 n11_5 123.2
Rh12_17 n12_17 n12_18 27.84
Rh10_3 n10_3 n10_4 31.75
Rv19_21 n19_21 n20_21 11.28
Rv8_15 n8_15 n9_15 568.7
Rh23_11 n23_11 n23_12 626.1
D11_13 n11_13 g11_13 dm
Rv2_1 n2_1 n3_1 109
Rg22_2 g22_2 0 1852
D17_7 n17_7 g17_7 dm
Rh21_15 n21_15 n21_16 162.7
Rg23_13 g23_13 0 2111
Rv22_5 n22_5 n23_5 10.97
Rh20_2 n20_2 n20_3 167.4
Rh21_0 n21_0 n21_1 10.4
Rh18_12 n18_12 n18_13 17.38
Rh23_19 n23_19 n23_20 123.6
Rg1_7 g1_7 0 4871
Rh6_15 n6_15 n6_16 43
Rh16_20 n16_20 n16_21 91.07
Rh13_2 n13_2 n13_3 286.1
Rh21_2 n21_2 n21_3 865.7
Rh3_3 n3_3 n3_4 26.19
Rv12_8 n12_8 n13_8 458.5
Rg23_1 g23_1 0 4053
Rh14_12 n14_12 n14_13 11.77
Rh6_22 n6_22 n6_23 14.13
Rv8_7 n8_7 n9_7 75.27
D12_8 n12_8 g12_8 dm
Rh1_3 n1_3 n1_4 492.5
Rh2_22 n2_22 n2_23 44.06
Rh11_12 n11_12 n11_13 310.1
Rv10_4 n10_4 n11_4 414.3
Rv11_6 n11_6 n12_6 52.34
Rh9_22 n9_22 n9_23 11.02
Rh1_17 n1_17 n1_18 120
Rh6_12 n6_12 n6_13 201.4
Rh4_4 n4_4 n4_5 16.18
Rv15_13 n15_13 n16_13 77.04
Rh21_7 n21_7 n21_8 18.21
Rv14_2 n14_2 n15_2 519
Rv17_15 n17_15 n18_15 14.35
Rh18_13 n18_13 n18_14 594.8
Rh5_4 n5_4 n5_5 170
Rh5_15 n5_15 n5_16 69.51
Rg20_20 g20_20 0 377.6
Rv11_5 n11_5 n12_5 173.8
Rh7_2 n7_2 n7_3 100.7
Rv10_10 n10_10 n11_10 312.3
Rv19_2 n19_2 n20_2 617.5
Rh12_2 n12_2 n12_3 205.9
Rh22_11 n22_11 n22_12 45.67
Rv13_2 n13_2 n14_2 163.1
Rh4_7 n4_7 n4_8 630
Rh12_1 n12_1 n12_2 70.02
Rv9_5 n9_5 n10_5 12.06
Rg18_18 g18_18 0 1214
Rv3_9 n3_9 n4_9 394.1
Rv5_16 n5_16 n6_16 30.4
Rv6_14 n6_14 n7_14 45.13
Rh16_18 n16_18 n16_19 44.79
Rh11_10 n11_10 n11_11 293.5
Rv6_19 n6_19 n7_19 10.98
Rh4_2 n4_2 n4_3 25.79
D21_7 n21_7 g21_7 dm
Rv6_12 n6_12 n7_12 193.6
Rv0_18 n0_18 n1_18 129.7
Rv12_0 n12_0 n13_0 308.7
Rh14_16 n14_16 n14_17 188.4
Rh17_0 n17_0 n17_1 400.6
Rg9_3 g9_3 0 1038
Rv20_22 n20_22 n21_22 47.23
Rv5_8 n5_8 n6_8 708.2
Rh8_15 n8_15 n8_16 105.5
Rv20_11 n20_11 n21_11 14.94
Rh13_8 n13_8 n13_9 40.83
Rv6_0 n6_0 n7_0 39
Rh17_7 n17_7 n17_8 115.9
Rv21_11 n21_11 n22_11 36.27
Rv13_3 n13_3 n14_3 113
Rh13_15 n13_15 n13_16 168.4
Rh19_13 n19_13 n19_14 37.52
Rv7_22 n7_22 n8_22 196.3
Rv8_9 n8_9 n9_9 97.76
Rh4_12 n4_12 n4_13 731.8
Rh15_3 n15_3 n15_4 575.7
Rh15_7 n15_7 n15_8 897
Rh5_21 n5_21 n5_22 89.95
Rg19_13 g19_13 0 565.3
D18_6 n18_6 g18_6 dm
Rh0_17 n0_17 n0_18 37.98
Rv2_14 n2_14 n3_14 14.67
Rh0_12 n0_12 n0_13 27.11
Rg14_6 g14_6 0 129.4
Rv3_11 n3_11 n4_11 61.63
Rh9_11 n9_11 n9_12 251.7
Rh20_17 n20_17 n20_18 25.26
Rv14_12 n14_12 n15_12 13.23
Rg6_22 g6_22 0 1574
Rv0_8 n0_8 n1_8 777.2
Rv8_17 n8_17 n9_17 42.03
Rh22_12 n22_12 n22_13 31.74
Rh11_21 n11_21 n11_22 20.14
Rv5_10 n5_10 n6_10 452.4
D9_7 n9_7 g9_7 dm
Rv8_10 n8_10 n9_10 28.19
Rg10_22 g10_22 0 1333
Rh21_4 n21_4 n21_5 330.9
Rv9_6 n9_6 n10_6 412.9
Rh20_0 n20_0 n20_1 62.84
Rg13_15 g13_15 0 762.1
Rv16_0 n16_0 n17_0 130.1
Rg7_9 g7_9 0 655.9
Rg10_2 g10_2 0 4020
Rv18_19 n18_19 n19_19 40.16
Rv7_21 n7_21 n8_21 32.8
D12_0 n12_0 g12_0 dm
D22_14 n22_14 g22_14 dm
Rh22_17 n22_17 n22_18 11.54
Rv16_1 n16_1 n17_1 47.57
Rv17_23 n17_23 n18_23 70.94
Rh14_9 n14_9 n14_10 13.01
Rh4_0 n4_0 n4_1 255.9
Rv9_1 n9_1 n10_1 327.7
Rg6_2 g6_2 0 574.1
D22_18 n22_18 g22_18 dm
Rv22_20 n22_20 n23_20 35.26
Rh18_3 n18_3 n18_4 991.6
Rh21_22 n21_22 n21_23 18.02
Rv13_1 n13_1 n14_1 670.3
D10_14 n10_14 g10_14 dm
Rv12_23 n12_23 n13_23 178.6
Rv17_21 n17_21 n18_21 157.1
Rv20_15 n20_15 n21_15 16.28
Rh21_13 n21_13 n21_14 26.84
Rh21_19 n21_19 n21_20 195
Rh16_16 n16_16 n16_17 100.5
Rh18_19 n18_19 n18_20 41.26
Rh9_12 n9_12 n9_13 705.7
Rh20_8 n20_8 n20_9 33.94
Rv18_20 n18_20 n19_20 148.8
Rv16_3 n16_3 n17_3 16.19
Rh19_12 n19_12 n19_13 519.7
Rv3_19 n3_19 n4_19 572.1
Rv22_8 n22_8 n23_8 933.2
D3_21 n3_21 g3_21 dm
Rv16_22 n16_22 n17_22 709.4
Rh20_4 n20_4 n20_5 49.36
Rv9_23 n9_23 n10_23 162.7
Rv17_6 n17_6 n18_6 911
Rh21_12 n21_12 n21_13 245.9
Rh7_13 n7_13 n7_14 310.7
Rv2_0 n2_0 n3_0 302.7
Rh9_21 n9_21 n9_22 23.97
Rh20_21 n20_21 n20_22 122.9
Rh17_8 n17_8 n17_9 19.8
Rh15_2 n15_2 n15_3 66.88
Rv16_7 n16_7 n17_7 621.8
Rg13_19 g13_19 0 2503
Rv16_5 n16_5 n17_5 274.6
Rv2_13 n2_13 n3_13 482.5
D13_11 n13_11 g13_11 dm
D5_15 n5_15 g5_15 dm
Rv0_22 n0_22 n1_22 264.5
Rv18_5 n18_5 n19_5 106.8
Rv19_18 n19_18 n20_18 877
Rv3_14 n3_14 n4_14 862.6
Rh8_17 n8_17 n8_18 583.5
Rv17_20 n17_20 n18_20 36.94
Rh0_19 n0_19 n0_20 192.6
Rv15_12 n15_12 n16_12 12.03
Rv18_9 n18_9 n19_9 82.59
Rg4_0 g4_0 0 580.1
Rh11_3 n11_3 n11_4 65.76
Rv14_11 n14_11 n15_11 648.9
Rh1_12 n1_12 n1_13 11.46
Rh17_2 n17_2 n17_3 966
D19_21 n19_21 g19_21 dm
Rh5_0 n5_0 n5_1 126.6
Rg20_0 g20_0 0 141
Rv8_4 n8_4 n9_4 167.8
Rv10_19 n10_19 n11_19 232.7
Rg20_12 g20_12 0 2160
Rv20_6 n20_6 n21_6 69.07
Rv19_12 n19_12 n20_12 151.1
Rv19_0 n19_0 n20_0 135.5
Rv6_11 n6_11 n7_11 78.67
Rv4_23 n4_23 n5_23 18.65
Rg4_20 g4_20 0 2157
Rv14_4 n14_4 n15_4 688.1
Rv2_3 n2_3 n3_3 549.6
Rv11_13 n11_13 n12_13 181.7
D17_19 n17_19 g17_19 dm
D3_13 n3_13 g3_13 dm
Rh3_14 n3_14 n3_15 39.56
Rg5_23 g5_23 0 1931
Rv4_4 n4_4 n5_4 214.7
Rh4_3 n4_3 n4_4 73.43
Rh3_0 n3_0 n3_1 59.31
Rg19_21 g19_21 0 112.8
Rh2_17 n2_17 n2_18 16.56
Rv20_5 n20_5 n21_5 16.08
Rg18_14 g18_14 0 760.7
Rh13_20 n13_20 n13_21 29.07
Rv14_10 n14_10 n15_10 84.29
Rv18_21 n18_21 n19_21 897.8
Rh22_8 n22_8 n22_9 229.8
Rh8_0 n8_0 n8_1 138.4
Rh5_17 n5_17 n5_18 307.6
Rv19_4 n19_4 n20_4 492.8
Rh4_18 n4_18 n4_19 329.8
Rh8_19 n8_19 n8_20 55.36
Rh14_4 n14_4 n14_5 144.7
Rv19_23 n19_23 n20_23 802.3
Rv12_20 n12_20 n13_20 42.96
Rv11_4 n11_4 n12_4 40.8
Rv21_9 n21_9 n22_9 116.3
Rv4_8 n4_8 n5_8 45.24
Rh3_12 n3_12 n3_13 141.8
Rv22_9 n22_9 n23_9 159.3
Rv8_13 n8_13 n9_13 196.3
Rv6_6 n6_6 n7_6 121.9
Rh1_15 n1_15 n1_16 21.91
D18_18 n18_18 g18_18 dm
Rh14_11 n14_11 n14_12 478.6
Rh22_0 n22_0 n22_1 15
Rv14_9 n14_9 n15_9 57.41
Rh20_6 n20_6 n20_7 127.5
Rv0_0 n0_0 n1_0 495.3
Rh5_18 n5_18 n5_19 663
Rh6_5 n6_5 n6_6 26.94
D13_15 n13_15 g13_15 dm
Rg13_23 g13_23 0 1861
Rh16_0 n16_0 n16_1 30.96
Rh17_13 n17_13 n17_14 34
Rh23_8 n23_8 n23_9 134.5
D3_5 n3_5 g3_5 dm
Rv0_1 n0_1 n1_1 32.37
Rh13_5 n13_5 n13_6 270.1
Rv8_19 n8_19 n9_19 252.7
Rh21_5 n21_5 n21_6 28.65
Rh15_12 n15_12 n15_13 931.9
Rh11_19 n11_19 n11_20 33.82
Rg15_21 g15_21 0 6232
Rv20_16 n20_16 n21_16 646.8
Rh7_7 n7_7 n7_8 106.8
Rh14_13 n14_13 n14_14 480
Rv6_10 n6_10 n7_10 36.44
Rv21_5 n21_5 n22_5 35.41
Rv22_13 n22_13 n23_13 12.08
Rv12_5 n12_5 n13_5 162.2
Rv1_15 n1_15 n2_15 101
D23_13 n23_13 g23_13 dm
Rv15_21 n15_21 n16_21 411
Rh18_8 n18_8 n18_9 147.6
Rv7_19 n7_19 n8_19 504.2
Rh5_14 n5_14 n5_15 30.15
Rh4_8 n4_8 n4_9 25.22
Rg9_11 g9_11 0 348.2
Rv19_7 n19_7 n20_7 91.8
Rg9_19 g9_19 0 6577
Rh23_22 n23_22 n23_23 114.9
Rv14_6 n14_6 n15_6 20.16
Rg5_15 g5_15 0 8029
Rh18_1 n18_1 n18_2 775.3
Rv1_21 n1_21 n2_21 820.8
Rv17_19 n17_19 n18_19 495.7
Rh10_2 n10_2 n10_3 35.19
Rg1_15 g1_15 0 2340
Rh10_16 n10_16 n10_17 114
Rh3_20 n3_20 n3_21 11.91
Rh3_4 n3_4 n3_5 430.6
D5_7 n5_7 g5_7 dm
Rv10_0 n10_0 n11_0 25.89
Rg13_3 g13_3 0 565.7
Rh21_8 n21_8 n21_9 132.3
Rh4_9 n4_9 n4_10 942.1
D22_10 n22_10 g22_10 dm
Rg12_20 g12_20 0 740.9
D12_20 n12_20 g12_20 dm
Rh23_17 n23_17 n23_18 26.92
D0_12 n0_12 g0_12 dm
Rh7_5 n7_5 n7_6 932.8
Rv0_14 n0_14 n1_14 98.09
Rh0_21 n0_21 n0_22 17.45
Rh1_16 n1_16 n1_17 920.8
Rh1_19 n1_19 n1_20 803.4
Rh10_18 n10_18 n10_19 40.7
Rh0_18 n0_18 n0_19 473.3
Rh14_17 n14_17 n14_18 236.3
Rg4_4 g4_4 0 757.6
Rh6_6 n6_6 n6_7 911.8
D1_23 n1_23 g1_23 dm
Rh18_21 n18_21 n18_22 125.9
Rv4_21 n4_21 n5_21 161.4
Rh7_3 n7_3 n7_4 14.26
Rv19_16 n19_16 n20_16 358.1
Rh12_8 n12_8 n12_9 14.12
Rh21_10 n21_10 n21_11 165.2
Rh10_8 n10_8 n10_9 58.41
Rh1_11 n1_11 n1_12 61.17
Rv20_14 n20_14 n21_14 17.07
D14_18 n14_18 g14_18 dm
Rv18_10 n18_10 n19_10 39.69
D3_9 n3_9 g3_9 dm
Rg15_5 g15_5 0 480.8
Rh1_21 n1_21 n1_22 124.7
Rv0_4 n0_4 n1_4 11.39
Rv1_1 n1_1 n2_1 40.43
Rh11_4 n11_4 n11_5 944.5
Rv21_18 n21_18 n22_18 240
Rv17_2 n17_2 n18_2 369.7
D9_15 n9_15 g9_15 dm
Rh5_22 n5_22 n5_23 201.4
Rv8_20 n8_20 n9_20 154.6
Rv6_13 n6_13 n7_13 60.39
Rg16_0 g16_0 0 584.1
Rg15_9 g15_9 0 2635
Rh15_18 n15_18 n15_19 14.84
Rh23_18 n23_18 n23_19 74
Rh2_10 n2_10 n2_11 22.62
Rg17_3 g17_3 0 8706
Rh5_10 n5_10 n5_11 375
Rg15_13 g15_13 0 8921
Rh0_20 n0_20 n0_21 966.2
D2_2 n2_2 g2_2 dm
Rv4_10 n4_10 n5_10 26.67
Rh10_14 n10_14 n10_15 139.7
Rv14_3 n14_3 n15_3 58.38
Rg8_20 g8_20 0 190.2
Rv14_17 n14_17 n15_17 491.2
Rv1_7 n1_7 n2_7 254.7
Rh22_7 n22_7 n22_8 14.76
Rg22_10 g22_10 0 6688
Rh11_8 n11_8 n11_9 71.08
Rh23_21 n23_21 n23_22 34.82
Rv12_14 n12_14 n13_14 132.5
Rv6_22 n6_22 n7_22 186.5
D16_20 n16_20 g16_20 dm
Rh16_19 n16_19 n16_20 13.73
Rh14_21 n14_21 n14_22 13.19
D12_4 n12_4 g12_4 dm
Rh3_2 n3_2 n3_3 630.4
Rv0_17 n0_17 n1_17 11.04
Rh3_18 n3_18 n3_19 67.97
Rh17_3 n17_3 n17_4 254.6
Rh10_12 n10_12 n10_13 332.8
Rv21_21 n21_21 n22_21 45.72
Rh12_10 n12_10 n12_11 105.4
Rv7_23 n7_23 n8_23 68.13
Rh8_18 n8_18 n8_19 242.7
Rh8_7 n8_7 n8_8 198.5
Rh12_19 n12_19 n12_20 11.51
Rv5_3 n5_3 n6_3 48.06
Rv19_5 n19_5 n20_5 84.87
Rv6_9 n6_9 n7_9 31.1
Rv16_13 n16_13 n17_13 42.39
Rg18_2 g18_2 0 3518
D7_5 n7_5 g7_5 dm
Rv3_15 n3_15 n4_15 41
Rh13_21 n13_21 n13_22 84.17
D21_11 n21_11 g21_11 dm
Rv2_6 n2_6 n3_6 49.22
Rh22_19 n22_19 n22_20 189.1
Rv11_11 n11_11 n12_11 96.7
D6_22 n6_22 g6_22 dm
Rv0_15 n0_15 n1_15 28.96
Rh22_22 n22_22 n22_23 789.5
Rv7_20 n7_20 n8_20 61.86
Rv0_2 n0_2 n1_2 79.25
D5_19 n5_19 g5_19 dm
Rh12_4 n12_4 n12_5 240.4
Rv0_10 n0_10 n1_10 121
Rh6_4 n6_4 n6_5 870.1
Rv11_2 n11_2 n12_2 466.9
Rh22_6 n22_6 n22_7 40.8
Rg20_4 g20_4 0 232.2
Rv1_12 n1_12 n2_12 12.22
D9_11 n9_11 g9_11 dm
Rv19_10 n19_10 n20_10 10.87
Rh23_20 n23_20 n23_21 31.68
Rv21_19 n21_19 n22_19 420.6
Rv2_11 n2_11 n3_11 395.3
Rg22_22 g22_22 0 102.5
Rh12_18 n12_18 n12_19 259
Rv7_9 n7_9 n8_9 662.2
Rv5_7 n5_7 n6_7 604.7
Rv9_3 n9_3 n10_3 49.66
Rh18_6 n18_6 n18_7 94.22
D18_22 n18_22 g18_22 dm
Rv7_0 n7_0 n8_0 96.94
Rh7_10 n7_10 n7_11 11.57
Rv7_14 n7_14 n8_14 73.33
Rv2_10 n2_10 n3_10 147.5
Rv18_1 n18_1 n19_1 394.7
Rg8_4 g8_4 0 2560
Rh18_4 n18_4 n18_5 25.28
D1_3 n1_3 g1_3 dm
Rh2_21 n2_21 n2_22 265
D15_17 n15_17 g15_17 dm
Rh12_14 n12_14 n12_15 29.12
Rv1_19 n1_19 n2_19 143.1
Rv21_10 n21_10 n22_10 19.85
Rv6_4 n6_4 n7_4 16.7
Rh5_9 n5_9 n5_10 82.33
Rv11_10 n11_10 n12_10 624.9
Rv14_13 n14_13 n15_13 12.18
D10_22 n10_22 g10_22 dm
Rg21_11 g21_11 0 4488
Rh0_4 n0_4 n0_5 15.41
Rv1_14 n1_14 n2_14 61.26
Rh0_2 n0_2 n0_3 97.92
Rv12_21 n12_21 n13_21 333.6
Rh23_2 n23_2 n23_3 163
Rh6_20 n6_20 n6_21 30.73
Rg4_8 g4_8 0 172.1
Rv11_14 n11_14 n12_14 181.4
Rv13_6 n13_6 n14_6 30.27
Rv21_3 n21_3 n22_3 75.95
Rv15_5 n15_5 n16_5 276.8
Rv3_6 n3_6 n4_6 20.91
Rh5_1 n5_1 n5_2 11.98
Rh17_16 n17_16 n17_17 13.98
Rg10_14 g10_14 0 4136
Rv11_22 n11_22 n12_22 85.94
D20_12 n20_12 g20_12 dm
D15_21 n15_21 g15_21 dm
D11_1 n11_1 g11_1 dm
D14_22 n14_22 g14_22 dm
Rh23_5 n23_5 n23_6 228
Rh15_17 n15_17 n15_18 15.16
D10_10 n10_10 g10_10 dm
Rh7_20 n7_20 n7_21 80.65
Rh10_5 n10_5 n10_6 885.6
Rh19_11 n19_11 n19_12 22.09
Rg17_11 g17_11 0 3707
Rh19_7 n19_7 n19_8 315.3
Rh18_17 n18_17 n18_18 433.6
Rv18_3 n18_3 n19_3 32.59
Rv5_9 n5_9 n6_9 35.84
Rg21_15 g21_15 0 7826
Rv12_1 n12_1 n13_1 51.33
Rh16_4 n16_4 n16_5 201.9
D15_13 n15_13 g15_13 dm
Rg22_18 g22_18 0 604.8
Rh16_17 n16_17 n16_18 19.84
Rh22_1 n22_1 n22_2 254.6
Rh2_9 n2_9 n2_10 11.37
Rv1_22 n1_22 n2_22 369.2
D23_17 n23_17 g23_17 dm
Rv14_21 n14_21 n15_21 741.9
D13_7 n13_7 g13_7 dm
Rg22_6 g22_6 0 2966
Rg3_1 g3_1 0 4821
Rh6_16 n6_16 n6_17 612.4
Rv4_14 n4_14 n5_14 935.4
Rv11_18 n11_18 n12_18 49.99
Rv15_8 n15_8 n16_8 511.8
Rg6_14 g6_14 0 830
Rv9_17 n9_17 n10_17 159
Rv8_16 n8_16 n9_16 340.5
Rv9_22 n9_22 n10_22 179.9
Rh20_14 n20_14 n20_15 645.9
Rh17_11 n17_11 n17_12 285.7
Rv22_0 n22_0 n23_0 119.6
Rv2_8 n2_8 n3_8 82.47
Rh19_22 n19_22 n19_23 32.1
Rv18_11 n18_11 n19_11 10.26
Rh2_1 n2_1 n2_2 415.2
Rv15_22 n15_22 n16_22 40.5
Rh5_3 n5_3 n5_4 454
D9_3 n9_3 g9_3 dm
Rh7_15 n7_15 n7_16 20.69
Rv2_22 n2_22 n3_22 88.62
Rh13_11 n13_11 n13_12 12.9
Rh9_4 n9_4 n9_5 107.2
Rv10_12 n10_12 n11_12 885.2
Rg6_10 g6_10 0 5829
Rv0_21 n0_21 n1_21 46.28
Rh7_8 n7_8 n7_9 38.63
Rh12_5 n12_5 n12_6 238.7
Rh14_2 n14_2 n14_3 393.4
D16_16 n16_16 g16_16 dm
Rv4_15 n4_15 n5_15 282.4
Rg17_15 g17_15 0 836.8
Rv17_12 n17_12 n18_12 123.4
Rv9_8 n9_8 n10_8 829.6
Rv8_1 n8_1 n9_1 18.9
Rh13_18 n13_18 n13_19 63.01
Rv19_3 n19_3 n20_3 627.3
Rh20_13 n20_13 n20_14 38.77
Rh17_19 n17_19 n17_20 54.48
Rh11_7 n11_7 n11_8 10.16
Rv17_18 n17_18 n18_18 11.06
Rh0_6 n0_6 n0_7 334.6
Rv12_9 n12_9 n13_9 54.5
Rv16_17 n16_17 n17_17 674.3
Rg12_12 g12_12 0 3501
Rg16_8 g16_8 0 223.6
Rh23_14 n23_14 n23_15 12.82
Rv3_8 n3_8 n4_8 27.62
Rg1_23 g1_23 0 413.3
Rv22_19 n22_19 n23_19 30.49
Rv4_1 n4_1 n5_1 49.42
Rv1_18 n1_18 n2_18 106.5
Rv16_9 n16_9 n17_9 55.04
Rh10_10 n10_10 n10_11 17.22
Rh13_1 n13_1 n13_2 77.12
Rh23_3 n23_3 n23_4 550.5
Rv0_20 n0_20 n1_20 524.7
Rh8_1 n8_1 n8_2 51.27
Rv18_4 n18_4 n19_4 311.6
Rv5_18 n5_18 n6_18 57.09
Rv11_8 n11_8 n12_8 64.64
Rh12_7 n12_7 n12_8 591.6
Rh9_1 n9_1 n9_2 137.7
Rg1_3 g1_3 0 1229
Rv20_2 n20_2 n21_2 980.8
Rv3_16 n3_16 n4_16 41.76
Rv1_3 n1_3 n2_3 102.5
Rv10_22 n10_22 n11_22 35.91
Rh14_19 n14_19 n14_20 182.9
Rv1_9 n1_9 n2_9 104
Rh8_12 n8_12 n8_13 651.4
D19_1 n19_1 g19_1 dm
D8_0 n8_0 g8_0 dm
Rh22_13 n22_13 n22_14 230.4
Rh6_2 n6_2 n6_3 42.32
Rh16_8 n16_8 n16_9 460.5
Rh6_7 n6_7 n6_8 237.9
Rv0_5 n0_5 n1_5 73.37
Rv19_6 n19_6 n20_6 55.62
Rg0_8 g0_8 0 161.3
Rh2_0 n2_0 n2_1 592.1
Rg7_17 g7_17 0 127.8
Rg9_23 g9_23 0 2040
Rh7_0 n7_0 n7_1 384
Rv2_18 n2_18 n3_18 13.77
Rh19_5 n19_5 n19_6 58.46
Rv6_7 n6_7 n7_7 210.7
Rh16_10 n16_10 n16_11 110.2
Rh9_14 n9_14 n9_15 73.42
Rv1_13 n1_13 n2_13 925.5
D7_17 n7_17 g7_17 dm
Rv15_2 n15_2 n16_2 25.05
D4_12 n4_12 g4_12 dm
Rh22_20 n22_20 n22_21 228.7
Rv1_6 n1_6 n2_6 22.18
Rv2_20 n2_20 n3_20 35.14
Rv15_19 n15_19 n16_19 291.9
Rv10_9 n10_9 n11_9 412.2
Rh18_14 n18_14 n18_15 874.1
Rv6_8 n6_8 n7_8 121.1
Rh1_5 n1_5 n1_6 30.58
Rv13_5 n13_5 n14_5 52.74
Rv10_18 n10_18 n11_18 62.92
D4_16 n4_16 g4_16 dm
Rh22_18 n22_18 n22_19 62.9
Rh10_9 n10_9 n10_10 16.45
Rh3_9 n3_9 n3_10 893.7
Rh16_5 n16_5 n16_6 946.4
Rv7_2 n7_2 n8_2 389
Rg19_5 g19_5 0 4781
Rh18_20 n18_20 n18_21 103
Rh7_18 n7_18 n7_19 413.5
Rh11_11 n11_11 n11_12 314.4
D16_12 n16_12 g16_12 dm
Rv12_11 n12_11 n13_11 202.4
Rg21_19 g21_19 0 109
Rh18_5 n18_5 n18_6 347.3
Rh19_17 n19_17 n19_18 93.67
Rh15_11 n15_11 n15_12 86.76
Rh7_22 n7_22 n7_23 11.19
Rv12_17 n12_17 n13_17 846.4
Rv17_3 n17_3 n18_3 311.4
Rh5_2 n5_2 n5_3 539.9
Rv3_17 n3_17 n4_17 307.4
Rh19_21 n19_21 n19_22 28.74
Rh5_13 n5_13 n5_14 589
Rv4_22 n4_22 n5_22 595
Rv10_20 n10_20 n11_20 197.4
Rh4_10 n4_10 n4_11 47.66
Rh20_16 n20_16 n20_17 59.26
Rh6_8 n6_8 n6_9 32.97
Rh1_1 n1_1 n1_2 219.1
Rv21_22 n21_22 n22_22 19.06
D12_16 n12_16 g12_16 dm
Rh23_16 n23_16 n23_17 22.4
Rv16_6 n16_6 n17_6 252.7
Rh16_13 n16_13 n16_14 200.6
Rh0_11 n0_11 n0_12 755.6
Rv10_16 n10_16 n11_16 10.04
Rv22_21 n22_21 n23_21 44.02
Rh19_0 n19_0 n19_1 296.7
Rv6_2 n6_2 n7_2 13.36
Rh21_6 n21_6 n21_7 258.5
Rv22_23 n22_23 n23_23 404.7
Rh3_15 n3_15 n3_16 563.7
Rg12_8 g12_8 0 9808
Rv9_16 n9_16 n10_16 829.6
Rh17_10 n17_10 n17_11 23.4
Rg7_5 g7_5 0 7363
Rv20_13 n20_13 n21_13 103.7
Rh13_9 n13_9 n13_10 62.23
D14_2 n14_2 g14_2 dm
Rv14_7 n14_7 n15_7 10.72
Rh11_14 n11_14 n11_15 65.16
Rh14_6 n14_6 n14_7 328.9
Rv14_23 n14_23 n15_23 162.4
Rg8_12 g8_12 0 121.4
Rh7_9 n7_9 n7_10 19.2
Rg21_7 g21_7 0 8794
Rg11_13 g11_13 0 6803
Rv1_20 n1_20 n2_20 34.56
Rh16_7 n16_7 n16_8 117.8
Rv20_3 n20_3 n21_3 117.2
Rh15_22 n15_22 n15_23 514.9
Rh2_20 n2_20 n2_21 21.69
Rv4_9 n4_9 n5_9 367.6
Rv18_15 n18_15 n19_15 126.7
Rv18_7 n18_7 n19_7 391.3
Rg16_20 g16_20 0 469.1
.model dm D(IS=1e-14 N=1.2)
.op
.end
