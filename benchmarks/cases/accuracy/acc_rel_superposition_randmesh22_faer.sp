Superposition on a random 22x22 resistor mesh: V1 + V2 + I3 versus the three single-source solves
* bench.id: acc_rel_superposition_randmesh22_faer
* bench.group: accuracy
* bench.title: Superposition v(V1+V2+I3) = v(V1) + v(V2) + v(I3) on a random 22x22 mesh (R log-uniform 1e-2..1e2): 4 copies, 4 relation nodes
* bench.probes: v(r_5_5), v(r_11_19), v(r_19_11), v(r_20_2), v(fn5_5), v(fn11_19), v(fn19_11), v(fn20_2)
* bench.tol.rel: 0
* bench.tol.abs: 1e-12
* bench.expect: match
* bench.oracle: dc_linear
* bench.size: 1958
* bench.tags: linear, op, mesh, relation, twin_block, ill_conditioned, reference_free, superposition
* bench.est_rss_mib: 32
* bench.note: Same relation as superposition_randmesh14 on a 22x22 mesh: 4 copies, 1958 unknowns, FaerSupernodal. Gate tol.abs 1e-12 V (full scale 1 V): RustSpice |r-1| <= 5.8e-15 (|rs - ngspice-tight| <= 1.5e-14), ngspice-tight <= 1.2e-14, python dense oracle 0, so the gate sits 68x above RustSpice and 80x above ngspice. Regression anchor for the faer tier.
rfrh0_0 fn0_0 fn0_1 0.07949
rfrv0_0 fn0_0 fn1_0 0.043191
rfrh0_1 fn0_1 fn0_2 0.028901
rfrv0_1 fn0_1 fn1_1 0.77446
rfrh0_2 fn0_2 fn0_3 2.1612
rfrv0_2 fn0_2 fn1_2 0.05834
rfrh0_3 fn0_3 fn0_4 0.16298
rfrv0_3 fn0_3 fn1_3 21.178
rfrh0_4 fn0_4 fn0_5 5.4182
rfrv0_4 fn0_4 fn1_4 2.4593
rfrh0_5 fn0_5 fn0_6 0.46846
rfrv0_5 fn0_5 fn1_5 4.968
rfrh0_6 fn0_6 fn0_7 0.02753
rfrv0_6 fn0_6 fn1_6 0.13939
rfrh0_7 fn0_7 fn0_8 6.0318
rfrv0_7 fn0_7 fn1_7 60.963
rfrh0_8 fn0_8 fn0_9 0.21165
rfrv0_8 fn0_8 fn1_8 1.6668
rfrh0_9 fn0_9 fn0_10 0.010995
rfrv0_9 fn0_9 fn1_9 0.023165
rfrh0_10 fn0_10 fn0_11 16.849
rfrv0_10 fn0_10 fn1_10 10.344
rfrh0_11 fn0_11 fn0_12 2.5996
rfrv0_11 fn0_11 fn1_11 3.9229
rfrh0_12 fn0_12 fn0_13 0.011808
rfrv0_12 fn0_12 fn1_12 0.19891
rfrh0_13 fn0_13 fn0_14 34.492
rfrv0_13 fn0_13 fn1_13 13.64
rfrh0_14 fn0_14 fn0_15 0.024922
rfrv0_14 fn0_14 fn1_14 0.13267
rfrh0_15 fn0_15 fn0_16 0.40219
rfrv0_15 fn0_15 fn1_15 1.7994
rfrh0_16 fn0_16 fn0_17 0.26296
rfrv0_16 fn0_16 fn1_16 0.38977
rfrh0_17 fn0_17 fn0_18 1.202
rfrv0_17 fn0_17 fn1_17 0.30597
rfrh0_18 fn0_18 fn0_19 0.23269
rfrv0_18 fn0_18 fn1_18 0.031318
rfrh0_19 fn0_19 fn0_20 1.0647
rfrv0_19 fn0_19 fn1_19 6.0872
rfrh0_20 fn0_20 fn0_21 0.25332
rfrv0_20 fn0_20 fn1_20 3.5917
rfrv0_21 fn0_21 fn1_21 0.85048
rfrh1_0 fn1_0 fn1_1 0.6922
rfrv1_0 fn1_0 fn2_0 45.621
rfrh1_1 fn1_1 fn1_2 0.71431
rfrv1_1 fn1_1 fn2_1 0.13417
rfrh1_2 fn1_2 fn1_3 0.013207
rfrv1_2 fn1_2 fn2_2 0.54203
rfrh1_3 fn1_3 fn1_4 5.5036
rfrv1_3 fn1_3 fn2_3 5.0865
rfrh1_4 fn1_4 fn1_5 10.943
rfrv1_4 fn1_4 fn2_4 1.2935
rfrh1_5 fn1_5 fn1_6 34.522
rfrv1_5 fn1_5 fn2_5 0.13683
rfrh1_6 fn1_6 fn1_7 0.14296
rfrv1_6 fn1_6 fn2_6 0.020727
rfrh1_7 fn1_7 fn1_8 0.29661
rfrv1_7 fn1_7 fn2_7 69.16
rfrh1_8 fn1_8 fn1_9 0.013871
rfrv1_8 fn1_8 fn2_8 0.38808
rfrh1_9 fn1_9 fn1_10 0.72185
rfrv1_9 fn1_9 fn2_9 82.573
rfrh1_10 fn1_10 fn1_11 0.016368
rfrv1_10 fn1_10 fn2_10 34.725
rfrh1_11 fn1_11 fn1_12 15.726
rfrv1_11 fn1_11 fn2_11 40.729
rfrh1_12 fn1_12 fn1_13 0.1815
rfrv1_12 fn1_12 fn2_12 0.339
rfrh1_13 fn1_13 fn1_14 80.753
rfrv1_13 fn1_13 fn2_13 0.17824
rfrh1_14 fn1_14 fn1_15 0.015231
rfrv1_14 fn1_14 fn2_14 0.26242
rfrh1_15 fn1_15 fn1_16 2.1893
rfrv1_15 fn1_15 fn2_15 0.039898
rfrh1_16 fn1_16 fn1_17 65.903
rfrv1_16 fn1_16 fn2_16 6.0463
rfrh1_17 fn1_17 fn1_18 1.712
rfrv1_17 fn1_17 fn2_17 7.8001
rfrh1_18 fn1_18 fn1_19 0.41694
rfrv1_18 fn1_18 fn2_18 1.8557
rfrh1_19 fn1_19 fn1_20 0.12409
rfrv1_19 fn1_19 fn2_19 68.908
rfrh1_20 fn1_20 fn1_21 0.40098
rfrv1_20 fn1_20 fn2_20 0.015704
rfrv1_21 fn1_21 fn2_21 2.9761
rfrh2_0 fn2_0 fn2_1 4.1782
rfrv2_0 fn2_0 fn3_0 32.687
rfrh2_1 fn2_1 fn2_2 10.885
rfrv2_1 fn2_1 fn3_1 92.17
rfrh2_2 fn2_2 fn2_3 0.5774
rfrv2_2 fn2_2 fn3_2 14.271
rfrh2_3 fn2_3 fn2_4 0.025447
rfrv2_3 fn2_3 fn3_3 0.011217
rfrh2_4 fn2_4 fn2_5 57.129
rfrv2_4 fn2_4 fn3_4 5.6204
rfrh2_5 fn2_5 fn2_6 12.873
rfrv2_5 fn2_5 fn3_5 66.15
rfrh2_6 fn2_6 fn2_7 4.167
rfrv2_6 fn2_6 fn3_6 29.546
rfrh2_7 fn2_7 fn2_8 11.991
rfrv2_7 fn2_7 fn3_7 0.84034
rfrh2_8 fn2_8 fn2_9 1.5378
rfrv2_8 fn2_8 fn3_8 0.77671
rfrh2_9 fn2_9 fn2_10 0.97199
rfrv2_9 fn2_9 fn3_9 0.031234
rfrh2_10 fn2_10 fn2_11 48.476
rfrv2_10 fn2_10 fn3_10 1.6643
rfrh2_11 fn2_11 fn2_12 7.9116
rfrv2_11 fn2_11 fn3_11 0.40806
rfrh2_12 fn2_12 fn2_13 0.04472
rfrv2_12 fn2_12 fn3_12 4.545
rfrh2_13 fn2_13 fn2_14 0.034361
rfrv2_13 fn2_13 fn3_13 36.836
rfrh2_14 fn2_14 fn2_15 26.16
rfrv2_14 fn2_14 fn3_14 0.20188
rfrh2_15 fn2_15 fn2_16 0.62895
rfrv2_15 fn2_15 fn3_15 2.3787
rfrh2_16 fn2_16 fn2_17 0.012442
rfrv2_16 fn2_16 fn3_16 0.019225
rfrh2_17 fn2_17 fn2_18 18.08
rfrv2_17 fn2_17 fn3_17 6.437
rfrh2_18 fn2_18 fn2_19 0.018971
rfrv2_18 fn2_18 fn3_18 0.24233
rfrh2_19 fn2_19 fn2_20 7.7019
rfrv2_19 fn2_19 fn3_19 0.17618
rfrh2_20 fn2_20 fn2_21 0.015317
rfrv2_20 fn2_20 fn3_20 1.8787
rfrv2_21 fn2_21 fn3_21 19.61
rfrh3_0 fn3_0 fn3_1 1.0689
rfrv3_0 fn3_0 fn4_0 0.2415
rfrh3_1 fn3_1 fn3_2 0.46929
rfrv3_1 fn3_1 fn4_1 0.89046
rfrh3_2 fn3_2 fn3_3 13.198
rfrv3_2 fn3_2 fn4_2 4.9925
rfrh3_3 fn3_3 fn3_4 23
rfrv3_3 fn3_3 fn4_3 0.25447
rfrh3_4 fn3_4 fn3_5 0.019077
rfrv3_4 fn3_4 fn4_4 0.040085
rfrh3_5 fn3_5 fn3_6 9.1707
rfrv3_5 fn3_5 fn4_5 36.957
rfrh3_6 fn3_6 fn3_7 36.669
rfrv3_6 fn3_6 fn4_6 3.7385
rfrh3_7 fn3_7 fn3_8 0.13621
rfrv3_7 fn3_7 fn4_7 0.37056
rfrh3_8 fn3_8 fn3_9 2.2891
rfrv3_8 fn3_8 fn4_8 35.826
rfrh3_9 fn3_9 fn3_10 63.361
rfrv3_9 fn3_9 fn4_9 38.612
rfrh3_10 fn3_10 fn3_11 29.633
rfrv3_10 fn3_10 fn4_10 0.67233
rfrh3_11 fn3_11 fn3_12 4.1311
rfrv3_11 fn3_11 fn4_11 1.4558
rfrh3_12 fn3_12 fn3_13 9.9609
rfrv3_12 fn3_12 fn4_12 1.6093
rfrh3_13 fn3_13 fn3_14 0.67203
rfrv3_13 fn3_13 fn4_13 6.2123
rfrh3_14 fn3_14 fn3_15 40.961
rfrv3_14 fn3_14 fn4_14 9.9189
rfrh3_15 fn3_15 fn3_16 0.022801
rfrv3_15 fn3_15 fn4_15 7.8165
rfrh3_16 fn3_16 fn3_17 0.20934
rfrv3_16 fn3_16 fn4_16 0.36185
rfrh3_17 fn3_17 fn3_18 0.030169
rfrv3_17 fn3_17 fn4_17 0.39251
rfrh3_18 fn3_18 fn3_19 0.02581
rfrv3_18 fn3_18 fn4_18 3.5432
rfrh3_19 fn3_19 fn3_20 5.7127
rfrv3_19 fn3_19 fn4_19 24.462
rfrh3_20 fn3_20 fn3_21 0.47624
rfrv3_20 fn3_20 fn4_20 1.2544
rfrv3_21 fn3_21 fn4_21 0.015166
rfrh4_0 fn4_0 fn4_1 15.202
rfrv4_0 fn4_0 fn5_0 1.0369
rfrh4_1 fn4_1 fn4_2 68.81
rfrv4_1 fn4_1 fn5_1 3.4048
rfrh4_2 fn4_2 fn4_3 15.495
rfrv4_2 fn4_2 fn5_2 0.6625
rfrh4_3 fn4_3 fn4_4 0.35928
rfrv4_3 fn4_3 fn5_3 0.20089
rfrh4_4 fn4_4 fn4_5 38.517
rfrv4_4 fn4_4 fn5_4 41.402
rfrh4_5 fn4_5 fn4_6 0.010792
rfrv4_5 fn4_5 fn5_5 3.86
rfrh4_6 fn4_6 fn4_7 0.63189
rfrv4_6 fn4_6 fn5_6 35.075
rfrh4_7 fn4_7 fn4_8 25.152
rfrv4_7 fn4_7 fn5_7 0.41562
rfrh4_8 fn4_8 fn4_9 31.334
rfrv4_8 fn4_8 fn5_8 0.075579
rfrh4_9 fn4_9 fn4_10 76
rfrv4_9 fn4_9 fn5_9 0.32575
rfrh4_10 fn4_10 fn4_11 2.6932
rfrv4_10 fn4_10 fn5_10 54.979
rfrh4_11 fn4_11 fn4_12 0.36634
rfrv4_11 fn4_11 fn5_11 55.475
rfrh4_12 fn4_12 fn4_13 5.7295
rfrv4_12 fn4_12 fn5_12 0.13068
rfrh4_13 fn4_13 fn4_14 8.8078
rfrv4_13 fn4_13 fn5_13 0.65371
rfrh4_14 fn4_14 fn4_15 0.015192
rfrv4_14 fn4_14 fn5_14 0.015676
rfrh4_15 fn4_15 fn4_16 0.013824
rfrv4_15 fn4_15 fn5_15 5.5302
rfrh4_16 fn4_16 fn4_17 0.073462
rfrv4_16 fn4_16 fn5_16 0.1036
rfrh4_17 fn4_17 fn4_18 0.45409
rfrv4_17 fn4_17 fn5_17 0.074468
rfrh4_18 fn4_18 fn4_19 0.18253
rfrv4_18 fn4_18 fn5_18 0.247
rfrh4_19 fn4_19 fn4_20 0.12481
rfrv4_19 fn4_19 fn5_19 10.966
rfrh4_20 fn4_20 fn4_21 0.072396
rfrv4_20 fn4_20 fn5_20 72.642
rfrv4_21 fn4_21 fn5_21 0.10097
rfrh5_0 fn5_0 fn5_1 5.9482
rfrv5_0 fn5_0 fn6_0 0.12867
rfrh5_1 fn5_1 fn5_2 0.27021
rfrv5_1 fn5_1 fn6_1 0.019452
rfrh5_2 fn5_2 fn5_3 0.078267
rfrv5_2 fn5_2 fn6_2 5.2072
rfrh5_3 fn5_3 fn5_4 0.010993
rfrv5_3 fn5_3 fn6_3 0.3659
rfrh5_4 fn5_4 fn5_5 1.8531
rfrv5_4 fn5_4 fn6_4 0.28307
rfrh5_5 fn5_5 fn5_6 0.012207
rfrv5_5 fn5_5 fn6_5 1.601
rfrh5_6 fn5_6 fn5_7 1.6014
rfrv5_6 fn5_6 fn6_6 0.38778
rfrh5_7 fn5_7 fn5_8 0.14101
rfrv5_7 fn5_7 fn6_7 0.025189
rfrh5_8 fn5_8 fn5_9 0.31118
rfrv5_8 fn5_8 fn6_8 0.11865
rfrh5_9 fn5_9 fn5_10 91.926
rfrv5_9 fn5_9 fn6_9 37.363
rfrh5_10 fn5_10 fn5_11 0.017907
rfrv5_10 fn5_10 fn6_10 50.476
rfrh5_11 fn5_11 fn5_12 0.048368
rfrv5_11 fn5_11 fn6_11 0.019765
rfrh5_12 fn5_12 fn5_13 0.063423
rfrv5_12 fn5_12 fn6_12 0.49729
rfrh5_13 fn5_13 fn5_14 31.728
rfrv5_13 fn5_13 fn6_13 0.36733
rfrh5_14 fn5_14 fn5_15 0.75078
rfrv5_14 fn5_14 fn6_14 5.9875
rfrh5_15 fn5_15 fn5_16 40.414
rfrv5_15 fn5_15 fn6_15 0.12894
rfrh5_16 fn5_16 fn5_17 0.011383
rfrv5_16 fn5_16 fn6_16 3.8191
rfrh5_17 fn5_17 fn5_18 0.043194
rfrv5_17 fn5_17 fn6_17 25.617
rfrh5_18 fn5_18 fn5_19 12.395
rfrv5_18 fn5_18 fn6_18 0.012598
rfrh5_19 fn5_19 fn5_20 0.44806
rfrv5_19 fn5_19 fn6_19 0.061961
rfrh5_20 fn5_20 fn5_21 68.951
rfrv5_20 fn5_20 fn6_20 85.972
rfrv5_21 fn5_21 fn6_21 2.8234
rfrh6_0 fn6_0 fn6_1 14.586
rfrv6_0 fn6_0 fn7_0 12.83
rfrh6_1 fn6_1 fn6_2 0.040898
rfrv6_1 fn6_1 fn7_1 26.512
rfrh6_2 fn6_2 fn6_3 19.629
rfrv6_2 fn6_2 fn7_2 2.5001
rfrh6_3 fn6_3 fn6_4 7.3621
rfrv6_3 fn6_3 fn7_3 0.042028
rfrh6_4 fn6_4 fn6_5 0.16336
rfrv6_4 fn6_4 fn7_4 2.3261
rfrh6_5 fn6_5 fn6_6 8.7872
rfrv6_5 fn6_5 fn7_5 1.2153
rfrh6_6 fn6_6 fn6_7 44.238
rfrv6_6 fn6_6 fn7_6 0.096877
rfrh6_7 fn6_7 fn6_8 0.32063
rfrv6_7 fn6_7 fn7_7 0.085631
rfrh6_8 fn6_8 fn6_9 3.604
rfrv6_8 fn6_8 fn7_8 0.01349
rfrh6_9 fn6_9 fn6_10 1.1105
rfrv6_9 fn6_9 fn7_9 50.037
rfrh6_10 fn6_10 fn6_11 3.4545
rfrv6_10 fn6_10 fn7_10 8.0998
rfrh6_11 fn6_11 fn6_12 0.047063
rfrv6_11 fn6_11 fn7_11 1.8334
rfrh6_12 fn6_12 fn6_13 1.4066
rfrv6_12 fn6_12 fn7_12 4.7506
rfrh6_13 fn6_13 fn6_14 22.016
rfrv6_13 fn6_13 fn7_13 2.1985
rfrh6_14 fn6_14 fn6_15 85.557
rfrv6_14 fn6_14 fn7_14 0.45874
rfrh6_15 fn6_15 fn6_16 0.018468
rfrv6_15 fn6_15 fn7_15 0.16103
rfrh6_16 fn6_16 fn6_17 1.2731
rfrv6_16 fn6_16 fn7_16 0.6574
rfrh6_17 fn6_17 fn6_18 26.855
rfrv6_17 fn6_17 fn7_17 0.121
rfrh6_18 fn6_18 fn6_19 0.19653
rfrv6_18 fn6_18 fn7_18 0.43759
rfrh6_19 fn6_19 fn6_20 0.20597
rfrv6_19 fn6_19 fn7_19 0.023812
rfrh6_20 fn6_20 fn6_21 0.10715
rfrv6_20 fn6_20 fn7_20 1.3
rfrv6_21 fn6_21 fn7_21 23.101
rfrh7_0 fn7_0 fn7_1 0.018708
rfrv7_0 fn7_0 fn8_0 0.097078
rfrh7_1 fn7_1 fn7_2 57.434
rfrv7_1 fn7_1 fn8_1 0.014227
rfrh7_2 fn7_2 fn7_3 88.777
rfrv7_2 fn7_2 fn8_2 35.224
rfrh7_3 fn7_3 fn7_4 0.097924
rfrv7_3 fn7_3 fn8_3 0.030583
rfrh7_4 fn7_4 fn7_5 0.048549
rfrv7_4 fn7_4 fn8_4 0.012701
rfrh7_5 fn7_5 fn7_6 0.012244
rfrv7_5 fn7_5 fn8_5 0.98937
rfrh7_6 fn7_6 fn7_7 0.010151
rfrv7_6 fn7_6 fn8_6 1.0946
rfrh7_7 fn7_7 fn7_8 33.567
rfrv7_7 fn7_7 fn8_7 1.1284
rfrh7_8 fn7_8 fn7_9 0.3389
rfrv7_8 fn7_8 fn8_8 18.839
rfrh7_9 fn7_9 fn7_10 0.23682
rfrv7_9 fn7_9 fn8_9 11.573
rfrh7_10 fn7_10 fn7_11 0.013642
rfrv7_10 fn7_10 fn8_10 0.019446
rfrh7_11 fn7_11 fn7_12 66.452
rfrv7_11 fn7_11 fn8_11 0.045887
rfrh7_12 fn7_12 fn7_13 9.1947
rfrv7_12 fn7_12 fn8_12 26.493
rfrh7_13 fn7_13 fn7_14 0.034554
rfrv7_13 fn7_13 fn8_13 41.919
rfrh7_14 fn7_14 fn7_15 5.2951
rfrv7_14 fn7_14 fn8_14 0.014956
rfrh7_15 fn7_15 fn7_16 0.17365
rfrv7_15 fn7_15 fn8_15 0.30346
rfrh7_16 fn7_16 fn7_17 0.049829
rfrv7_16 fn7_16 fn8_16 1.1352
rfrh7_17 fn7_17 fn7_18 55.118
rfrv7_17 fn7_17 fn8_17 0.62125
rfrh7_18 fn7_18 fn7_19 0.93914
rfrv7_18 fn7_18 fn8_18 0.28286
rfrh7_19 fn7_19 fn7_20 0.45716
rfrv7_19 fn7_19 fn8_19 0.012854
rfrh7_20 fn7_20 fn7_21 13.526
rfrv7_20 fn7_20 fn8_20 0.45196
rfrv7_21 fn7_21 fn8_21 1.6401
rfrh8_0 fn8_0 fn8_1 0.18978
rfrv8_0 fn8_0 fn9_0 28
rfrh8_1 fn8_1 fn8_2 0.019762
rfrv8_1 fn8_1 fn9_1 2.9465
rfrh8_2 fn8_2 fn8_3 0.019322
rfrv8_2 fn8_2 fn9_2 0.24656
rfrh8_3 fn8_3 fn8_4 0.081712
rfrv8_3 fn8_3 fn9_3 0.11402
rfrh8_4 fn8_4 fn8_5 0.16974
rfrv8_4 fn8_4 fn9_4 76.296
rfrh8_5 fn8_5 fn8_6 86.831
rfrv8_5 fn8_5 fn9_5 23.337
rfrh8_6 fn8_6 fn8_7 45.065
rfrv8_6 fn8_6 fn9_6 0.012011
rfrh8_7 fn8_7 fn8_8 30.255
rfrv8_7 fn8_7 fn9_7 0.026531
rfrh8_8 fn8_8 fn8_9 60.089
rfrv8_8 fn8_8 fn9_8 2.717
rfrh8_9 fn8_9 fn8_10 49.3
rfrv8_9 fn8_9 fn9_9 0.042969
rfrh8_10 fn8_10 fn8_11 5.8846
rfrv8_10 fn8_10 fn9_10 0.016633
rfrh8_11 fn8_11 fn8_12 10.579
rfrv8_11 fn8_11 fn9_11 0.027153
rfrh8_12 fn8_12 fn8_13 0.52587
rfrv8_12 fn8_12 fn9_12 5.0432
rfrh8_13 fn8_13 fn8_14 0.021393
rfrv8_13 fn8_13 fn9_13 0.15694
rfrh8_14 fn8_14 fn8_15 0.056522
rfrv8_14 fn8_14 fn9_14 0.057144
rfrh8_15 fn8_15 fn8_16 1.2492
rfrv8_15 fn8_15 fn9_15 0.021173
rfrh8_16 fn8_16 fn8_17 86.665
rfrv8_16 fn8_16 fn9_16 0.014018
rfrh8_17 fn8_17 fn8_18 0.53852
rfrv8_17 fn8_17 fn9_17 1.6931
rfrh8_18 fn8_18 fn8_19 0.015522
rfrv8_18 fn8_18 fn9_18 0.064091
rfrh8_19 fn8_19 fn8_20 47.913
rfrv8_19 fn8_19 fn9_19 12.003
rfrh8_20 fn8_20 fn8_21 69.14
rfrv8_20 fn8_20 fn9_20 0.019354
rfrv8_21 fn8_21 fn9_21 70.289
rfrh9_0 fn9_0 fn9_1 0.037657
rfrv9_0 fn9_0 fn10_0 0.011899
rfrh9_1 fn9_1 fn9_2 68.636
rfrv9_1 fn9_1 fn10_1 0.010146
rfrh9_2 fn9_2 fn9_3 36.579
rfrv9_2 fn9_2 fn10_2 0.087712
rfrh9_3 fn9_3 fn9_4 0.24812
rfrv9_3 fn9_3 fn10_3 4.0003
rfrh9_4 fn9_4 fn9_5 0.6411
rfrv9_4 fn9_4 fn10_4 0.24967
rfrh9_5 fn9_5 fn9_6 0.13597
rfrv9_5 fn9_5 fn10_5 0.30713
rfrh9_6 fn9_6 fn9_7 0.33231
rfrv9_6 fn9_6 fn10_6 12.937
rfrh9_7 fn9_7 fn9_8 0.02877
rfrv9_7 fn9_7 fn10_7 1.7902
rfrh9_8 fn9_8 fn9_9 0.037947
rfrv9_8 fn9_8 fn10_8 0.16194
rfrh9_9 fn9_9 fn9_10 0.48947
rfrv9_9 fn9_9 fn10_9 0.016513
rfrh9_10 fn9_10 fn9_11 0.025579
rfrv9_10 fn9_10 fn10_10 2.3882
rfrh9_11 fn9_11 fn9_12 62.779
rfrv9_11 fn9_11 fn10_11 0.092934
rfrh9_12 fn9_12 fn9_13 0.092593
rfrv9_12 fn9_12 fn10_12 2.1705
rfrh9_13 fn9_13 fn9_14 1.824
rfrv9_13 fn9_13 fn10_13 3.1857
rfrh9_14 fn9_14 fn9_15 2.2657
rfrv9_14 fn9_14 fn10_14 0.30124
rfrh9_15 fn9_15 fn9_16 33.562
rfrv9_15 fn9_15 fn10_15 5.3346
rfrh9_16 fn9_16 fn9_17 76.59
rfrv9_16 fn9_16 fn10_16 0.38294
rfrh9_17 fn9_17 fn9_18 10.855
rfrv9_17 fn9_17 fn10_17 0.049634
rfrh9_18 fn9_18 fn9_19 1.7504
rfrv9_18 fn9_18 fn10_18 0.068466
rfrh9_19 fn9_19 fn9_20 0.058177
rfrv9_19 fn9_19 fn10_19 2.9708
rfrh9_20 fn9_20 fn9_21 10.85
rfrv9_20 fn9_20 fn10_20 2.6414
rfrv9_21 fn9_21 fn10_21 10.029
rfrh10_0 fn10_0 fn10_1 89.715
rfrv10_0 fn10_0 fn11_0 1.2959
rfrh10_1 fn10_1 fn10_2 6.6347
rfrv10_1 fn10_1 fn11_1 12.851
rfrh10_2 fn10_2 fn10_3 11.756
rfrv10_2 fn10_2 fn11_2 9.6522
rfrh10_3 fn10_3 fn10_4 8.3217
rfrv10_3 fn10_3 fn11_3 0.028322
rfrh10_4 fn10_4 fn10_5 46.974
rfrv10_4 fn10_4 fn11_4 0.014447
rfrh10_5 fn10_5 fn10_6 6.8916
rfrv10_5 fn10_5 fn11_5 85.05
rfrh10_6 fn10_6 fn10_7 0.19606
rfrv10_6 fn10_6 fn11_6 0.01041
rfrh10_7 fn10_7 fn10_8 0.070847
rfrv10_7 fn10_7 fn11_7 0.04512
rfrh10_8 fn10_8 fn10_9 0.021327
rfrv10_8 fn10_8 fn11_8 4.9031
rfrh10_9 fn10_9 fn10_10 0.012852
rfrv10_9 fn10_9 fn11_9 0.13062
rfrh10_10 fn10_10 fn10_11 5.7498
rfrv10_10 fn10_10 fn11_10 0.013581
rfrh10_11 fn10_11 fn10_12 7.7532
rfrv10_11 fn10_11 fn11_11 76.953
rfrh10_12 fn10_12 fn10_13 8.1451
rfrv10_12 fn10_12 fn11_12 0.032028
rfrh10_13 fn10_13 fn10_14 0.081907
rfrv10_13 fn10_13 fn11_13 3.5273
rfrh10_14 fn10_14 fn10_15 0.75035
rfrv10_14 fn10_14 fn11_14 0.011616
rfrh10_15 fn10_15 fn10_16 3.5379
rfrv10_15 fn10_15 fn11_15 0.030288
rfrh10_16 fn10_16 fn10_17 0.18264
rfrv10_16 fn10_16 fn11_16 0.081921
rfrh10_17 fn10_17 fn10_18 40.984
rfrv10_17 fn10_17 fn11_17 73.659
rfrh10_18 fn10_18 fn10_19 0.36118
rfrv10_18 fn10_18 fn11_18 0.51524
rfrh10_19 fn10_19 fn10_20 0.4518
rfrv10_19 fn10_19 fn11_19 38.747
rfrh10_20 fn10_20 fn10_21 11.446
rfrv10_20 fn10_20 fn11_20 0.029769
rfrv10_21 fn10_21 fn11_21 0.21627
rfrh11_0 fn11_0 fn11_1 0.4376
rfrv11_0 fn11_0 fn12_0 32.465
rfrh11_1 fn11_1 fn11_2 0.64741
rfrv11_1 fn11_1 fn12_1 38.728
rfrh11_2 fn11_2 fn11_3 0.12581
rfrv11_2 fn11_2 fn12_2 35.427
rfrh11_3 fn11_3 fn11_4 0.93395
rfrv11_3 fn11_3 fn12_3 92.382
rfrh11_4 fn11_4 fn11_5 49.931
rfrv11_4 fn11_4 fn12_4 0.050761
rfrh11_5 fn11_5 fn11_6 0.094384
rfrv11_5 fn11_5 fn12_5 0.44967
rfrh11_6 fn11_6 fn11_7 2.6361
rfrv11_6 fn11_6 fn12_6 0.88625
rfrh11_7 fn11_7 fn11_8 3.78
rfrv11_7 fn11_7 fn12_7 0.72062
rfrh11_8 fn11_8 fn11_9 13.661
rfrv11_8 fn11_8 fn12_8 0.021202
rfrh11_9 fn11_9 fn11_10 0.19401
rfrv11_9 fn11_9 fn12_9 55.56
rfrh11_10 fn11_10 fn11_11 10.132
rfrv11_10 fn11_10 fn12_10 1.6738
rfrh11_11 fn11_11 fn11_12 22.573
rfrv11_11 fn11_11 fn12_11 27.079
rfrh11_12 fn11_12 fn11_13 2.0331
rfrv11_12 fn11_12 fn12_12 0.1529
rfrh11_13 fn11_13 fn11_14 0.1319
rfrv11_13 fn11_13 fn12_13 10.047
rfrh11_14 fn11_14 fn11_15 0.936
rfrv11_14 fn11_14 fn12_14 0.043377
rfrh11_15 fn11_15 fn11_16 7.8282
rfrv11_15 fn11_15 fn12_15 0.17466
rfrh11_16 fn11_16 fn11_17 5.1896
rfrv11_16 fn11_16 fn12_16 0.016062
rfrh11_17 fn11_17 fn11_18 3.4088
rfrv11_17 fn11_17 fn12_17 2.8552
rfrh11_18 fn11_18 fn11_19 0.033206
rfrv11_18 fn11_18 fn12_18 16.883
rfrh11_19 fn11_19 fn11_20 43.057
rfrv11_19 fn11_19 fn12_19 1.8508
rfrh11_20 fn11_20 fn11_21 2.3375
rfrv11_20 fn11_20 fn12_20 1.2772
rfrv11_21 fn11_21 fn12_21 0.018238
rfrh12_0 fn12_0 fn12_1 0.022209
rfrv12_0 fn12_0 fn13_0 0.17594
rfrh12_1 fn12_1 fn12_2 0.10643
rfrv12_1 fn12_1 fn13_1 0.21395
rfrh12_2 fn12_2 fn12_3 36.801
rfrv12_2 fn12_2 fn13_2 0.47588
rfrh12_3 fn12_3 fn12_4 0.025856
rfrv12_3 fn12_3 fn13_3 0.71022
rfrh12_4 fn12_4 fn12_5 2.2596
rfrv12_4 fn12_4 fn13_4 96.307
rfrh12_5 fn12_5 fn12_6 1.1732
rfrv12_5 fn12_5 fn13_5 65.869
rfrh12_6 fn12_6 fn12_7 14.797
rfrv12_6 fn12_6 fn13_6 0.012802
rfrh12_7 fn12_7 fn12_8 52.513
rfrv12_7 fn12_7 fn13_7 0.012495
rfrh12_8 fn12_8 fn12_9 32.679
rfrv12_8 fn12_8 fn13_8 0.018837
rfrh12_9 fn12_9 fn12_10 22.988
rfrv12_9 fn12_9 fn13_9 0.80923
rfrh12_10 fn12_10 fn12_11 0.78246
rfrv12_10 fn12_10 fn13_10 0.16827
rfrh12_11 fn12_11 fn12_12 19.646
rfrv12_11 fn12_11 fn13_11 0.013998
rfrh12_12 fn12_12 fn12_13 0.21072
rfrv12_12 fn12_12 fn13_12 0.74406
rfrh12_13 fn12_13 fn12_14 24.763
rfrv12_13 fn12_13 fn13_13 0.36897
rfrh12_14 fn12_14 fn12_15 0.16019
rfrv12_14 fn12_14 fn13_14 1.5729
rfrh12_15 fn12_15 fn12_16 0.081719
rfrv12_15 fn12_15 fn13_15 1.002
rfrh12_16 fn12_16 fn12_17 3.3612
rfrv12_16 fn12_16 fn13_16 0.040295
rfrh12_17 fn12_17 fn12_18 3.2454
rfrv12_17 fn12_17 fn13_17 76.096
rfrh12_18 fn12_18 fn12_19 8.5164
rfrv12_18 fn12_18 fn13_18 6.2662
rfrh12_19 fn12_19 fn12_20 1.1299
rfrv12_19 fn12_19 fn13_19 0.74627
rfrh12_20 fn12_20 fn12_21 57.7
rfrv12_20 fn12_20 fn13_20 3.7508
rfrv12_21 fn12_21 fn13_21 0.56683
rfrh13_0 fn13_0 fn13_1 60.786
rfrv13_0 fn13_0 fn14_0 0.034466
rfrh13_1 fn13_1 fn13_2 7.7366
rfrv13_1 fn13_1 fn14_1 5.733
rfrh13_2 fn13_2 fn13_3 3.7983
rfrv13_2 fn13_2 fn14_2 5.6392
rfrh13_3 fn13_3 fn13_4 28.539
rfrv13_3 fn13_3 fn14_3 1.1959
rfrh13_4 fn13_4 fn13_5 0.12794
rfrv13_4 fn13_4 fn14_4 0.18351
rfrh13_5 fn13_5 fn13_6 0.10368
rfrv13_5 fn13_5 fn14_5 2.6404
rfrh13_6 fn13_6 fn13_7 0.42065
rfrv13_6 fn13_6 fn14_6 32.205
rfrh13_7 fn13_7 fn13_8 0.014
rfrv13_7 fn13_7 fn14_7 0.056695
rfrh13_8 fn13_8 fn13_9 0.25379
rfrv13_8 fn13_8 fn14_8 0.15996
rfrh13_9 fn13_9 fn13_10 0.73884
rfrv13_9 fn13_9 fn14_9 2.5481
rfrh13_10 fn13_10 fn13_11 0.91974
rfrv13_10 fn13_10 fn14_10 0.62071
rfrh13_11 fn13_11 fn13_12 0.011752
rfrv13_11 fn13_11 fn14_11 0.010543
rfrh13_12 fn13_12 fn13_13 0.32596
rfrv13_12 fn13_12 fn14_12 80.324
rfrh13_13 fn13_13 fn13_14 0.35207
rfrv13_13 fn13_13 fn14_13 0.42935
rfrh13_14 fn13_14 fn13_15 0.053754
rfrv13_14 fn13_14 fn14_14 2.4196
rfrh13_15 fn13_15 fn13_16 0.037917
rfrv13_15 fn13_15 fn14_15 1.6089
rfrh13_16 fn13_16 fn13_17 0.55176
rfrv13_16 fn13_16 fn14_16 0.055745
rfrh13_17 fn13_17 fn13_18 0.095412
rfrv13_17 fn13_17 fn14_17 3.6819
rfrh13_18 fn13_18 fn13_19 0.33148
rfrv13_18 fn13_18 fn14_18 0.030714
rfrh13_19 fn13_19 fn13_20 44.442
rfrv13_19 fn13_19 fn14_19 88.966
rfrh13_20 fn13_20 fn13_21 26.064
rfrv13_20 fn13_20 fn14_20 3.1928
rfrv13_21 fn13_21 fn14_21 0.02761
rfrh14_0 fn14_0 fn14_1 0.28799
rfrv14_0 fn14_0 fn15_0 0.19308
rfrh14_1 fn14_1 fn14_2 2.6396
rfrv14_1 fn14_1 fn15_1 0.14575
rfrh14_2 fn14_2 fn14_3 0.29946
rfrv14_2 fn14_2 fn15_2 1.9543
rfrh14_3 fn14_3 fn14_4 0.09652
rfrv14_3 fn14_3 fn15_3 57.22
rfrh14_4 fn14_4 fn14_5 32.451
rfrv14_4 fn14_4 fn15_4 48.798
rfrh14_5 fn14_5 fn14_6 8.7874
rfrv14_5 fn14_5 fn15_5 0.01095
rfrh14_6 fn14_6 fn14_7 14.28
rfrv14_6 fn14_6 fn15_6 4.4055
rfrh14_7 fn14_7 fn14_8 37.396
rfrv14_7 fn14_7 fn15_7 6.531
rfrh14_8 fn14_8 fn14_9 18.645
rfrv14_8 fn14_8 fn15_8 62.476
rfrh14_9 fn14_9 fn14_10 6.9985
rfrv14_9 fn14_9 fn15_9 21.725
rfrh14_10 fn14_10 fn14_11 19.867
rfrv14_10 fn14_10 fn15_10 82.302
rfrh14_11 fn14_11 fn14_12 0.80469
rfrv14_11 fn14_11 fn15_11 39.431
rfrh14_12 fn14_12 fn14_13 0.13877
rfrv14_12 fn14_12 fn15_12 24.392
rfrh14_13 fn14_13 fn14_14 2.1861
rfrv14_13 fn14_13 fn15_13 1.4616
rfrh14_14 fn14_14 fn14_15 0.046352
rfrv14_14 fn14_14 fn15_14 2.0511
rfrh14_15 fn14_15 fn14_16 4.1102
rfrv14_15 fn14_15 fn15_15 1.79
rfrh14_16 fn14_16 fn14_17 29.144
rfrv14_16 fn14_16 fn15_16 0.3955
rfrh14_17 fn14_17 fn14_18 0.013147
rfrv14_17 fn14_17 fn15_17 0.19565
rfrh14_18 fn14_18 fn14_19 0.032432
rfrv14_18 fn14_18 fn15_18 8.2061
rfrh14_19 fn14_19 fn14_20 0.012133
rfrv14_19 fn14_19 fn15_19 6.893
rfrh14_20 fn14_20 fn14_21 3.5575
rfrv14_20 fn14_20 fn15_20 4.0947
rfrv14_21 fn14_21 fn15_21 0.66479
rfrh15_0 fn15_0 fn15_1 3.088
rfrv15_0 fn15_0 fn16_0 0.10379
rfrh15_1 fn15_1 fn15_2 0.041186
rfrv15_1 fn15_1 fn16_1 13.133
rfrh15_2 fn15_2 fn15_3 0.13033
rfrv15_2 fn15_2 fn16_2 0.49175
rfrh15_3 fn15_3 fn15_4 1.9923
rfrv15_3 fn15_3 fn16_3 0.018405
rfrh15_4 fn15_4 fn15_5 0.069036
rfrv15_4 fn15_4 fn16_4 0.34543
rfrh15_5 fn15_5 fn15_6 0.072768
rfrv15_5 fn15_5 fn16_5 5.9813
rfrh15_6 fn15_6 fn15_7 37.105
rfrv15_6 fn15_6 fn16_6 2.2721
rfrh15_7 fn15_7 fn15_8 83.341
rfrv15_7 fn15_7 fn16_7 0.022309
rfrh15_8 fn15_8 fn15_9 2.8302
rfrv15_8 fn15_8 fn16_8 2.1074
rfrh15_9 fn15_9 fn15_10 27.063
rfrv15_9 fn15_9 fn16_9 0.61585
rfrh15_10 fn15_10 fn15_11 0.96513
rfrv15_10 fn15_10 fn16_10 0.011365
rfrh15_11 fn15_11 fn15_12 6.392
rfrv15_11 fn15_11 fn16_11 16.312
rfrh15_12 fn15_12 fn15_13 1.1577
rfrv15_12 fn15_12 fn16_12 28.237
rfrh15_13 fn15_13 fn15_14 1.6716
rfrv15_13 fn15_13 fn16_13 46.113
rfrh15_14 fn15_14 fn15_15 0.018684
rfrv15_14 fn15_14 fn16_14 0.37943
rfrh15_15 fn15_15 fn15_16 11.504
rfrv15_15 fn15_15 fn16_15 0.51207
rfrh15_16 fn15_16 fn15_17 2.041
rfrv15_16 fn15_16 fn16_16 0.016679
rfrh15_17 fn15_17 fn15_18 0.12387
rfrv15_17 fn15_17 fn16_17 20.019
rfrh15_18 fn15_18 fn15_19 0.53111
rfrv15_18 fn15_18 fn16_18 0.11321
rfrh15_19 fn15_19 fn15_20 2.9985
rfrv15_19 fn15_19 fn16_19 0.18716
rfrh15_20 fn15_20 fn15_21 81.044
rfrv15_20 fn15_20 fn16_20 16.754
rfrv15_21 fn15_21 fn16_21 0.19383
rfrh16_0 fn16_0 fn16_1 0.14553
rfrv16_0 fn16_0 fn17_0 0.25127
rfrh16_1 fn16_1 fn16_2 2.126
rfrv16_1 fn16_1 fn17_1 0.26332
rfrh16_2 fn16_2 fn16_3 40.257
rfrv16_2 fn16_2 fn17_2 38.679
rfrh16_3 fn16_3 fn16_4 15.618
rfrv16_3 fn16_3 fn17_3 24.155
rfrh16_4 fn16_4 fn16_5 2.6809
rfrv16_4 fn16_4 fn17_4 0.7507
rfrh16_5 fn16_5 fn16_6 0.092602
rfrv16_5 fn16_5 fn17_5 0.57702
rfrh16_6 fn16_6 fn16_7 0.89986
rfrv16_6 fn16_6 fn17_6 4.4468
rfrh16_7 fn16_7 fn16_8 0.011547
rfrv16_7 fn16_7 fn17_7 65.22
rfrh16_8 fn16_8 fn16_9 0.56118
rfrv16_8 fn16_8 fn17_8 0.076466
rfrh16_9 fn16_9 fn16_10 0.26213
rfrv16_9 fn16_9 fn17_9 0.75643
rfrh16_10 fn16_10 fn16_11 0.020835
rfrv16_10 fn16_10 fn17_10 0.73866
rfrh16_11 fn16_11 fn16_12 0.015975
rfrv16_11 fn16_11 fn17_11 24.352
rfrh16_12 fn16_12 fn16_13 0.018113
rfrv16_12 fn16_12 fn17_12 0.13993
rfrh16_13 fn16_13 fn16_14 0.028306
rfrv16_13 fn16_13 fn17_13 0.022343
rfrh16_14 fn16_14 fn16_15 3.6791
rfrv16_14 fn16_14 fn17_14 0.1211
rfrh16_15 fn16_15 fn16_16 2.3388
rfrv16_15 fn16_15 fn17_15 25.679
rfrh16_16 fn16_16 fn16_17 0.02121
rfrv16_16 fn16_16 fn17_16 0.030382
rfrh16_17 fn16_17 fn16_18 1.5384
rfrv16_17 fn16_17 fn17_17 0.1474
rfrh16_18 fn16_18 fn16_19 0.76392
rfrv16_18 fn16_18 fn17_18 0.059424
rfrh16_19 fn16_19 fn16_20 25.688
rfrv16_19 fn16_19 fn17_19 0.92226
rfrh16_20 fn16_20 fn16_21 0.74295
rfrv16_20 fn16_20 fn17_20 3.086
rfrv16_21 fn16_21 fn17_21 0.19857
rfrh17_0 fn17_0 fn17_1 26.089
rfrv17_0 fn17_0 fn18_0 1.0646
rfrh17_1 fn17_1 fn17_2 30.062
rfrv17_1 fn17_1 fn18_1 0.96719
rfrh17_2 fn17_2 fn17_3 0.35974
rfrv17_2 fn17_2 fn18_2 0.17956
rfrh17_3 fn17_3 fn17_4 38.06
rfrv17_3 fn17_3 fn18_3 0.63562
rfrh17_4 fn17_4 fn17_5 72.881
rfrv17_4 fn17_4 fn18_4 0.040853
rfrh17_5 fn17_5 fn17_6 0.013455
rfrv17_5 fn17_5 fn18_5 0.063698
rfrh17_6 fn17_6 fn17_7 1.5303
rfrv17_6 fn17_6 fn18_6 69.104
rfrh17_7 fn17_7 fn17_8 88.285
rfrv17_7 fn17_7 fn18_7 0.29406
rfrh17_8 fn17_8 fn17_9 45.847
rfrv17_8 fn17_8 fn18_8 0.15453
rfrh17_9 fn17_9 fn17_10 79.987
rfrv17_9 fn17_9 fn18_9 0.26918
rfrh17_10 fn17_10 fn17_11 0.26713
rfrv17_10 fn17_10 fn18_10 0.031844
rfrh17_11 fn17_11 fn17_12 0.17586
rfrv17_11 fn17_11 fn18_11 0.18298
rfrh17_12 fn17_12 fn17_13 0.7229
rfrv17_12 fn17_12 fn18_12 3.6166
rfrh17_13 fn17_13 fn17_14 4.3613
rfrv17_13 fn17_13 fn18_13 0.31353
rfrh17_14 fn17_14 fn17_15 1.4887
rfrv17_14 fn17_14 fn18_14 8.0976
rfrh17_15 fn17_15 fn17_16 0.29057
rfrv17_15 fn17_15 fn18_15 1.1484
rfrh17_16 fn17_16 fn17_17 0.28407
rfrv17_16 fn17_16 fn18_16 0.030149
rfrh17_17 fn17_17 fn17_18 2.072
rfrv17_17 fn17_17 fn18_17 0.023885
rfrh17_18 fn17_18 fn17_19 84.05
rfrv17_18 fn17_18 fn18_18 0.01294
rfrh17_19 fn17_19 fn17_20 1.1397
rfrv17_19 fn17_19 fn18_19 1.3848
rfrh17_20 fn17_20 fn17_21 1.9116
rfrv17_20 fn17_20 fn18_20 2.016
rfrv17_21 fn17_21 fn18_21 0.029814
rfrh18_0 fn18_0 fn18_1 1.272
rfrv18_0 fn18_0 fn19_0 65.628
rfrh18_1 fn18_1 fn18_2 1.4798
rfrv18_1 fn18_1 fn19_1 44.141
rfrh18_2 fn18_2 fn18_3 0.40894
rfrv18_2 fn18_2 fn19_2 0.014347
rfrh18_3 fn18_3 fn18_4 0.061888
rfrv18_3 fn18_3 fn19_3 16.409
rfrh18_4 fn18_4 fn18_5 0.51091
rfrv18_4 fn18_4 fn19_4 0.27205
rfrh18_5 fn18_5 fn18_6 0.068644
rfrv18_5 fn18_5 fn19_5 1.6279
rfrh18_6 fn18_6 fn18_7 0.039196
rfrv18_6 fn18_6 fn19_6 0.029747
rfrh18_7 fn18_7 fn18_8 38.273
rfrv18_7 fn18_7 fn19_7 0.92358
rfrh18_8 fn18_8 fn18_9 49.525
rfrv18_8 fn18_8 fn19_8 1.4933
rfrh18_9 fn18_9 fn18_10 0.64314
rfrv18_9 fn18_9 fn19_9 0.11604
rfrh18_10 fn18_10 fn18_11 30.908
rfrv18_10 fn18_10 fn19_10 0.02018
rfrh18_11 fn18_11 fn18_12 2.2793
rfrv18_11 fn18_11 fn19_11 12.75
rfrh18_12 fn18_12 fn18_13 9.7473
rfrv18_12 fn18_12 fn19_12 0.62111
rfrh18_13 fn18_13 fn18_14 0.035547
rfrv18_13 fn18_13 fn19_13 0.016576
rfrh18_14 fn18_14 fn18_15 1.6198
rfrv18_14 fn18_14 fn19_14 0.047372
rfrh18_15 fn18_15 fn18_16 5.9411
rfrv18_15 fn18_15 fn19_15 0.28266
rfrh18_16 fn18_16 fn18_17 0.043261
rfrv18_16 fn18_16 fn19_16 23.663
rfrh18_17 fn18_17 fn18_18 7.7821
rfrv18_17 fn18_17 fn19_17 0.24854
rfrh18_18 fn18_18 fn18_19 0.35084
rfrv18_18 fn18_18 fn19_18 1.4105
rfrh18_19 fn18_19 fn18_20 0.7143
rfrv18_19 fn18_19 fn19_19 0.046045
rfrh18_20 fn18_20 fn18_21 0.016931
rfrv18_20 fn18_20 fn19_20 0.26183
rfrv18_21 fn18_21 fn19_21 0.34735
rfrh19_0 fn19_0 fn19_1 0.13413
rfrv19_0 fn19_0 fn20_0 39.031
rfrh19_1 fn19_1 fn19_2 62.609
rfrv19_1 fn19_1 fn20_1 0.568
rfrh19_2 fn19_2 fn19_3 0.85164
rfrv19_2 fn19_2 fn20_2 19.501
rfrh19_3 fn19_3 fn19_4 3.0974
rfrv19_3 fn19_3 fn20_3 46.255
rfrh19_4 fn19_4 fn19_5 2.0139
rfrv19_4 fn19_4 fn20_4 27.721
rfrh19_5 fn19_5 fn19_6 44.892
rfrv19_5 fn19_5 fn20_5 0.68149
rfrh19_6 fn19_6 fn19_7 0.022886
rfrv19_6 fn19_6 fn20_6 0.36386
rfrh19_7 fn19_7 fn19_8 0.22514
rfrv19_7 fn19_7 fn20_7 49.831
rfrh19_8 fn19_8 fn19_9 1.8627
rfrv19_8 fn19_8 fn20_8 0.65547
rfrh19_9 fn19_9 fn19_10 0.18912
rfrv19_9 fn19_9 fn20_9 0.84976
rfrh19_10 fn19_10 fn19_11 6.0006
rfrv19_10 fn19_10 fn20_10 28.601
rfrh19_11 fn19_11 fn19_12 4.5593
rfrv19_11 fn19_11 fn20_11 0.036837
rfrh19_12 fn19_12 fn19_13 0.30798
rfrv19_12 fn19_12 fn20_12 1.0266
rfrh19_13 fn19_13 fn19_14 0.028251
rfrv19_13 fn19_13 fn20_13 35.888
rfrh19_14 fn19_14 fn19_15 1.0322
rfrv19_14 fn19_14 fn20_14 14.578
rfrh19_15 fn19_15 fn19_16 10.072
rfrv19_15 fn19_15 fn20_15 12.278
rfrh19_16 fn19_16 fn19_17 0.040303
rfrv19_16 fn19_16 fn20_16 0.37718
rfrh19_17 fn19_17 fn19_18 0.29454
rfrv19_17 fn19_17 fn20_17 0.77113
rfrh19_18 fn19_18 fn19_19 0.019908
rfrv19_18 fn19_18 fn20_18 8.3733
rfrh19_19 fn19_19 fn19_20 0.1412
rfrv19_19 fn19_19 fn20_19 28.17
rfrh19_20 fn19_20 fn19_21 18.495
rfrv19_20 fn19_20 fn20_20 5.9805
rfrv19_21 fn19_21 fn20_21 87.024
rfrh20_0 fn20_0 fn20_1 0.039848
rfrv20_0 fn20_0 fn21_0 62.412
rfrh20_1 fn20_1 fn20_2 0.022554
rfrv20_1 fn20_1 fn21_1 0.05519
rfrh20_2 fn20_2 fn20_3 0.91308
rfrv20_2 fn20_2 fn21_2 0.12149
rfrh20_3 fn20_3 fn20_4 0.65365
rfrv20_3 fn20_3 fn21_3 0.062637
rfrh20_4 fn20_4 fn20_5 0.28101
rfrv20_4 fn20_4 fn21_4 0.014571
rfrh20_5 fn20_5 fn20_6 0.024432
rfrv20_5 fn20_5 fn21_5 6.5893
rfrh20_6 fn20_6 fn20_7 0.68363
rfrv20_6 fn20_6 fn21_6 10.852
rfrh20_7 fn20_7 fn20_8 2.7288
rfrv20_7 fn20_7 fn21_7 67.534
rfrh20_8 fn20_8 fn20_9 0.55671
rfrv20_8 fn20_8 fn21_8 2.036
rfrh20_9 fn20_9 fn20_10 0.0797
rfrv20_9 fn20_9 fn21_9 44.03
rfrh20_10 fn20_10 fn20_11 0.029079
rfrv20_10 fn20_10 fn21_10 51.95
rfrh20_11 fn20_11 fn20_12 0.013697
rfrv20_11 fn20_11 fn21_11 5.2514
rfrh20_12 fn20_12 fn20_13 5.1019
rfrv20_12 fn20_12 fn21_12 1.2833
rfrh20_13 fn20_13 fn20_14 3.8802
rfrv20_13 fn20_13 fn21_13 0.022293
rfrh20_14 fn20_14 fn20_15 7.8705
rfrv20_14 fn20_14 fn21_14 0.42301
rfrh20_15 fn20_15 fn20_16 8.7201
rfrv20_15 fn20_15 fn21_15 0.046761
rfrh20_16 fn20_16 fn20_17 50.796
rfrv20_16 fn20_16 fn21_16 0.42332
rfrh20_17 fn20_17 fn20_18 0.29557
rfrv20_17 fn20_17 fn21_17 3.6366
rfrh20_18 fn20_18 fn20_19 2.5958
rfrv20_18 fn20_18 fn21_18 22.279
rfrh20_19 fn20_19 fn20_20 0.046121
rfrv20_19 fn20_19 fn21_19 0.036349
rfrh20_20 fn20_20 fn20_21 5.7006
rfrv20_20 fn20_20 fn21_20 2.1644
rfrv20_21 fn20_21 fn21_21 0.14511
rfrh21_0 fn21_0 fn21_1 0.044466
rfrh21_1 fn21_1 fn21_2 0.011544
rfrh21_2 fn21_2 fn21_3 0.3283
rfrh21_3 fn21_3 fn21_4 0.010761
rfrh21_4 fn21_4 fn21_5 0.3853
rfrh21_5 fn21_5 fn21_6 2.0096
rfrh21_6 fn21_6 fn21_7 0.047863
rfrh21_7 fn21_7 fn21_8 6.4954
rfrh21_8 fn21_8 fn21_9 0.021558
rfrh21_9 fn21_9 fn21_10 3.3955
rfrh21_10 fn21_10 fn21_11 0.73929
rfrh21_11 fn21_11 fn21_12 0.010796
rfrh21_12 fn21_12 fn21_13 2.3408
rfrh21_13 fn21_13 fn21_14 6.763
rfrh21_14 fn21_14 fn21_15 0.28986
rfrh21_15 fn21_15 fn21_16 7.6391
rfrh21_16 fn21_16 fn21_17 56.591
rfrh21_17 fn21_17 fn21_18 26.955
rfrh21_18 fn21_18 fn21_19 43.674
rfrh21_19 fn21_19 fn21_20 0.05288
rfrh21_20 fn21_20 fn21_21 0.011858
rfp0 fp1 fn0_0 0.01
rfp1 fn0_21 0 0.01
rfp2 fn21_0 0 0.01
rfp3 fp2 fn21_21 0.01
vf1 fp1 0 DC 1.0
vf2 fp2 0 DC -0.7
if3 0 fn11_7 DC 0.5
rarh0_0 an0_0 an0_1 0.07949
rarv0_0 an0_0 an1_0 0.043191
rarh0_1 an0_1 an0_2 0.028901
rarv0_1 an0_1 an1_1 0.77446
rarh0_2 an0_2 an0_3 2.1612
rarv0_2 an0_2 an1_2 0.05834
rarh0_3 an0_3 an0_4 0.16298
rarv0_3 an0_3 an1_3 21.178
rarh0_4 an0_4 an0_5 5.4182
rarv0_4 an0_4 an1_4 2.4593
rarh0_5 an0_5 an0_6 0.46846
rarv0_5 an0_5 an1_5 4.968
rarh0_6 an0_6 an0_7 0.02753
rarv0_6 an0_6 an1_6 0.13939
rarh0_7 an0_7 an0_8 6.0318
rarv0_7 an0_7 an1_7 60.963
rarh0_8 an0_8 an0_9 0.21165
rarv0_8 an0_8 an1_8 1.6668
rarh0_9 an0_9 an0_10 0.010995
rarv0_9 an0_9 an1_9 0.023165
rarh0_10 an0_10 an0_11 16.849
rarv0_10 an0_10 an1_10 10.344
rarh0_11 an0_11 an0_12 2.5996
rarv0_11 an0_11 an1_11 3.9229
rarh0_12 an0_12 an0_13 0.011808
rarv0_12 an0_12 an1_12 0.19891
rarh0_13 an0_13 an0_14 34.492
rarv0_13 an0_13 an1_13 13.64
rarh0_14 an0_14 an0_15 0.024922
rarv0_14 an0_14 an1_14 0.13267
rarh0_15 an0_15 an0_16 0.40219
rarv0_15 an0_15 an1_15 1.7994
rarh0_16 an0_16 an0_17 0.26296
rarv0_16 an0_16 an1_16 0.38977
rarh0_17 an0_17 an0_18 1.202
rarv0_17 an0_17 an1_17 0.30597
rarh0_18 an0_18 an0_19 0.23269
rarv0_18 an0_18 an1_18 0.031318
rarh0_19 an0_19 an0_20 1.0647
rarv0_19 an0_19 an1_19 6.0872
rarh0_20 an0_20 an0_21 0.25332
rarv0_20 an0_20 an1_20 3.5917
rarv0_21 an0_21 an1_21 0.85048
rarh1_0 an1_0 an1_1 0.6922
rarv1_0 an1_0 an2_0 45.621
rarh1_1 an1_1 an1_2 0.71431
rarv1_1 an1_1 an2_1 0.13417
rarh1_2 an1_2 an1_3 0.013207
rarv1_2 an1_2 an2_2 0.54203
rarh1_3 an1_3 an1_4 5.5036
rarv1_3 an1_3 an2_3 5.0865
rarh1_4 an1_4 an1_5 10.943
rarv1_4 an1_4 an2_4 1.2935
rarh1_5 an1_5 an1_6 34.522
rarv1_5 an1_5 an2_5 0.13683
rarh1_6 an1_6 an1_7 0.14296
rarv1_6 an1_6 an2_6 0.020727
rarh1_7 an1_7 an1_8 0.29661
rarv1_7 an1_7 an2_7 69.16
rarh1_8 an1_8 an1_9 0.013871
rarv1_8 an1_8 an2_8 0.38808
rarh1_9 an1_9 an1_10 0.72185
rarv1_9 an1_9 an2_9 82.573
rarh1_10 an1_10 an1_11 0.016368
rarv1_10 an1_10 an2_10 34.725
rarh1_11 an1_11 an1_12 15.726
rarv1_11 an1_11 an2_11 40.729
rarh1_12 an1_12 an1_13 0.1815
rarv1_12 an1_12 an2_12 0.339
rarh1_13 an1_13 an1_14 80.753
rarv1_13 an1_13 an2_13 0.17824
rarh1_14 an1_14 an1_15 0.015231
rarv1_14 an1_14 an2_14 0.26242
rarh1_15 an1_15 an1_16 2.1893
rarv1_15 an1_15 an2_15 0.039898
rarh1_16 an1_16 an1_17 65.903
rarv1_16 an1_16 an2_16 6.0463
rarh1_17 an1_17 an1_18 1.712
rarv1_17 an1_17 an2_17 7.8001
rarh1_18 an1_18 an1_19 0.41694
rarv1_18 an1_18 an2_18 1.8557
rarh1_19 an1_19 an1_20 0.12409
rarv1_19 an1_19 an2_19 68.908
rarh1_20 an1_20 an1_21 0.40098
rarv1_20 an1_20 an2_20 0.015704
rarv1_21 an1_21 an2_21 2.9761
rarh2_0 an2_0 an2_1 4.1782
rarv2_0 an2_0 an3_0 32.687
rarh2_1 an2_1 an2_2 10.885
rarv2_1 an2_1 an3_1 92.17
rarh2_2 an2_2 an2_3 0.5774
rarv2_2 an2_2 an3_2 14.271
rarh2_3 an2_3 an2_4 0.025447
rarv2_3 an2_3 an3_3 0.011217
rarh2_4 an2_4 an2_5 57.129
rarv2_4 an2_4 an3_4 5.6204
rarh2_5 an2_5 an2_6 12.873
rarv2_5 an2_5 an3_5 66.15
rarh2_6 an2_6 an2_7 4.167
rarv2_6 an2_6 an3_6 29.546
rarh2_7 an2_7 an2_8 11.991
rarv2_7 an2_7 an3_7 0.84034
rarh2_8 an2_8 an2_9 1.5378
rarv2_8 an2_8 an3_8 0.77671
rarh2_9 an2_9 an2_10 0.97199
rarv2_9 an2_9 an3_9 0.031234
rarh2_10 an2_10 an2_11 48.476
rarv2_10 an2_10 an3_10 1.6643
rarh2_11 an2_11 an2_12 7.9116
rarv2_11 an2_11 an3_11 0.40806
rarh2_12 an2_12 an2_13 0.04472
rarv2_12 an2_12 an3_12 4.545
rarh2_13 an2_13 an2_14 0.034361
rarv2_13 an2_13 an3_13 36.836
rarh2_14 an2_14 an2_15 26.16
rarv2_14 an2_14 an3_14 0.20188
rarh2_15 an2_15 an2_16 0.62895
rarv2_15 an2_15 an3_15 2.3787
rarh2_16 an2_16 an2_17 0.012442
rarv2_16 an2_16 an3_16 0.019225
rarh2_17 an2_17 an2_18 18.08
rarv2_17 an2_17 an3_17 6.437
rarh2_18 an2_18 an2_19 0.018971
rarv2_18 an2_18 an3_18 0.24233
rarh2_19 an2_19 an2_20 7.7019
rarv2_19 an2_19 an3_19 0.17618
rarh2_20 an2_20 an2_21 0.015317
rarv2_20 an2_20 an3_20 1.8787
rarv2_21 an2_21 an3_21 19.61
rarh3_0 an3_0 an3_1 1.0689
rarv3_0 an3_0 an4_0 0.2415
rarh3_1 an3_1 an3_2 0.46929
rarv3_1 an3_1 an4_1 0.89046
rarh3_2 an3_2 an3_3 13.198
rarv3_2 an3_2 an4_2 4.9925
rarh3_3 an3_3 an3_4 23
rarv3_3 an3_3 an4_3 0.25447
rarh3_4 an3_4 an3_5 0.019077
rarv3_4 an3_4 an4_4 0.040085
rarh3_5 an3_5 an3_6 9.1707
rarv3_5 an3_5 an4_5 36.957
rarh3_6 an3_6 an3_7 36.669
rarv3_6 an3_6 an4_6 3.7385
rarh3_7 an3_7 an3_8 0.13621
rarv3_7 an3_7 an4_7 0.37056
rarh3_8 an3_8 an3_9 2.2891
rarv3_8 an3_8 an4_8 35.826
rarh3_9 an3_9 an3_10 63.361
rarv3_9 an3_9 an4_9 38.612
rarh3_10 an3_10 an3_11 29.633
rarv3_10 an3_10 an4_10 0.67233
rarh3_11 an3_11 an3_12 4.1311
rarv3_11 an3_11 an4_11 1.4558
rarh3_12 an3_12 an3_13 9.9609
rarv3_12 an3_12 an4_12 1.6093
rarh3_13 an3_13 an3_14 0.67203
rarv3_13 an3_13 an4_13 6.2123
rarh3_14 an3_14 an3_15 40.961
rarv3_14 an3_14 an4_14 9.9189
rarh3_15 an3_15 an3_16 0.022801
rarv3_15 an3_15 an4_15 7.8165
rarh3_16 an3_16 an3_17 0.20934
rarv3_16 an3_16 an4_16 0.36185
rarh3_17 an3_17 an3_18 0.030169
rarv3_17 an3_17 an4_17 0.39251
rarh3_18 an3_18 an3_19 0.02581
rarv3_18 an3_18 an4_18 3.5432
rarh3_19 an3_19 an3_20 5.7127
rarv3_19 an3_19 an4_19 24.462
rarh3_20 an3_20 an3_21 0.47624
rarv3_20 an3_20 an4_20 1.2544
rarv3_21 an3_21 an4_21 0.015166
rarh4_0 an4_0 an4_1 15.202
rarv4_0 an4_0 an5_0 1.0369
rarh4_1 an4_1 an4_2 68.81
rarv4_1 an4_1 an5_1 3.4048
rarh4_2 an4_2 an4_3 15.495
rarv4_2 an4_2 an5_2 0.6625
rarh4_3 an4_3 an4_4 0.35928
rarv4_3 an4_3 an5_3 0.20089
rarh4_4 an4_4 an4_5 38.517
rarv4_4 an4_4 an5_4 41.402
rarh4_5 an4_5 an4_6 0.010792
rarv4_5 an4_5 an5_5 3.86
rarh4_6 an4_6 an4_7 0.63189
rarv4_6 an4_6 an5_6 35.075
rarh4_7 an4_7 an4_8 25.152
rarv4_7 an4_7 an5_7 0.41562
rarh4_8 an4_8 an4_9 31.334
rarv4_8 an4_8 an5_8 0.075579
rarh4_9 an4_9 an4_10 76
rarv4_9 an4_9 an5_9 0.32575
rarh4_10 an4_10 an4_11 2.6932
rarv4_10 an4_10 an5_10 54.979
rarh4_11 an4_11 an4_12 0.36634
rarv4_11 an4_11 an5_11 55.475
rarh4_12 an4_12 an4_13 5.7295
rarv4_12 an4_12 an5_12 0.13068
rarh4_13 an4_13 an4_14 8.8078
rarv4_13 an4_13 an5_13 0.65371
rarh4_14 an4_14 an4_15 0.015192
rarv4_14 an4_14 an5_14 0.015676
rarh4_15 an4_15 an4_16 0.013824
rarv4_15 an4_15 an5_15 5.5302
rarh4_16 an4_16 an4_17 0.073462
rarv4_16 an4_16 an5_16 0.1036
rarh4_17 an4_17 an4_18 0.45409
rarv4_17 an4_17 an5_17 0.074468
rarh4_18 an4_18 an4_19 0.18253
rarv4_18 an4_18 an5_18 0.247
rarh4_19 an4_19 an4_20 0.12481
rarv4_19 an4_19 an5_19 10.966
rarh4_20 an4_20 an4_21 0.072396
rarv4_20 an4_20 an5_20 72.642
rarv4_21 an4_21 an5_21 0.10097
rarh5_0 an5_0 an5_1 5.9482
rarv5_0 an5_0 an6_0 0.12867
rarh5_1 an5_1 an5_2 0.27021
rarv5_1 an5_1 an6_1 0.019452
rarh5_2 an5_2 an5_3 0.078267
rarv5_2 an5_2 an6_2 5.2072
rarh5_3 an5_3 an5_4 0.010993
rarv5_3 an5_3 an6_3 0.3659
rarh5_4 an5_4 an5_5 1.8531
rarv5_4 an5_4 an6_4 0.28307
rarh5_5 an5_5 an5_6 0.012207
rarv5_5 an5_5 an6_5 1.601
rarh5_6 an5_6 an5_7 1.6014
rarv5_6 an5_6 an6_6 0.38778
rarh5_7 an5_7 an5_8 0.14101
rarv5_7 an5_7 an6_7 0.025189
rarh5_8 an5_8 an5_9 0.31118
rarv5_8 an5_8 an6_8 0.11865
rarh5_9 an5_9 an5_10 91.926
rarv5_9 an5_9 an6_9 37.363
rarh5_10 an5_10 an5_11 0.017907
rarv5_10 an5_10 an6_10 50.476
rarh5_11 an5_11 an5_12 0.048368
rarv5_11 an5_11 an6_11 0.019765
rarh5_12 an5_12 an5_13 0.063423
rarv5_12 an5_12 an6_12 0.49729
rarh5_13 an5_13 an5_14 31.728
rarv5_13 an5_13 an6_13 0.36733
rarh5_14 an5_14 an5_15 0.75078
rarv5_14 an5_14 an6_14 5.9875
rarh5_15 an5_15 an5_16 40.414
rarv5_15 an5_15 an6_15 0.12894
rarh5_16 an5_16 an5_17 0.011383
rarv5_16 an5_16 an6_16 3.8191
rarh5_17 an5_17 an5_18 0.043194
rarv5_17 an5_17 an6_17 25.617
rarh5_18 an5_18 an5_19 12.395
rarv5_18 an5_18 an6_18 0.012598
rarh5_19 an5_19 an5_20 0.44806
rarv5_19 an5_19 an6_19 0.061961
rarh5_20 an5_20 an5_21 68.951
rarv5_20 an5_20 an6_20 85.972
rarv5_21 an5_21 an6_21 2.8234
rarh6_0 an6_0 an6_1 14.586
rarv6_0 an6_0 an7_0 12.83
rarh6_1 an6_1 an6_2 0.040898
rarv6_1 an6_1 an7_1 26.512
rarh6_2 an6_2 an6_3 19.629
rarv6_2 an6_2 an7_2 2.5001
rarh6_3 an6_3 an6_4 7.3621
rarv6_3 an6_3 an7_3 0.042028
rarh6_4 an6_4 an6_5 0.16336
rarv6_4 an6_4 an7_4 2.3261
rarh6_5 an6_5 an6_6 8.7872
rarv6_5 an6_5 an7_5 1.2153
rarh6_6 an6_6 an6_7 44.238
rarv6_6 an6_6 an7_6 0.096877
rarh6_7 an6_7 an6_8 0.32063
rarv6_7 an6_7 an7_7 0.085631
rarh6_8 an6_8 an6_9 3.604
rarv6_8 an6_8 an7_8 0.01349
rarh6_9 an6_9 an6_10 1.1105
rarv6_9 an6_9 an7_9 50.037
rarh6_10 an6_10 an6_11 3.4545
rarv6_10 an6_10 an7_10 8.0998
rarh6_11 an6_11 an6_12 0.047063
rarv6_11 an6_11 an7_11 1.8334
rarh6_12 an6_12 an6_13 1.4066
rarv6_12 an6_12 an7_12 4.7506
rarh6_13 an6_13 an6_14 22.016
rarv6_13 an6_13 an7_13 2.1985
rarh6_14 an6_14 an6_15 85.557
rarv6_14 an6_14 an7_14 0.45874
rarh6_15 an6_15 an6_16 0.018468
rarv6_15 an6_15 an7_15 0.16103
rarh6_16 an6_16 an6_17 1.2731
rarv6_16 an6_16 an7_16 0.6574
rarh6_17 an6_17 an6_18 26.855
rarv6_17 an6_17 an7_17 0.121
rarh6_18 an6_18 an6_19 0.19653
rarv6_18 an6_18 an7_18 0.43759
rarh6_19 an6_19 an6_20 0.20597
rarv6_19 an6_19 an7_19 0.023812
rarh6_20 an6_20 an6_21 0.10715
rarv6_20 an6_20 an7_20 1.3
rarv6_21 an6_21 an7_21 23.101
rarh7_0 an7_0 an7_1 0.018708
rarv7_0 an7_0 an8_0 0.097078
rarh7_1 an7_1 an7_2 57.434
rarv7_1 an7_1 an8_1 0.014227
rarh7_2 an7_2 an7_3 88.777
rarv7_2 an7_2 an8_2 35.224
rarh7_3 an7_3 an7_4 0.097924
rarv7_3 an7_3 an8_3 0.030583
rarh7_4 an7_4 an7_5 0.048549
rarv7_4 an7_4 an8_4 0.012701
rarh7_5 an7_5 an7_6 0.012244
rarv7_5 an7_5 an8_5 0.98937
rarh7_6 an7_6 an7_7 0.010151
rarv7_6 an7_6 an8_6 1.0946
rarh7_7 an7_7 an7_8 33.567
rarv7_7 an7_7 an8_7 1.1284
rarh7_8 an7_8 an7_9 0.3389
rarv7_8 an7_8 an8_8 18.839
rarh7_9 an7_9 an7_10 0.23682
rarv7_9 an7_9 an8_9 11.573
rarh7_10 an7_10 an7_11 0.013642
rarv7_10 an7_10 an8_10 0.019446
rarh7_11 an7_11 an7_12 66.452
rarv7_11 an7_11 an8_11 0.045887
rarh7_12 an7_12 an7_13 9.1947
rarv7_12 an7_12 an8_12 26.493
rarh7_13 an7_13 an7_14 0.034554
rarv7_13 an7_13 an8_13 41.919
rarh7_14 an7_14 an7_15 5.2951
rarv7_14 an7_14 an8_14 0.014956
rarh7_15 an7_15 an7_16 0.17365
rarv7_15 an7_15 an8_15 0.30346
rarh7_16 an7_16 an7_17 0.049829
rarv7_16 an7_16 an8_16 1.1352
rarh7_17 an7_17 an7_18 55.118
rarv7_17 an7_17 an8_17 0.62125
rarh7_18 an7_18 an7_19 0.93914
rarv7_18 an7_18 an8_18 0.28286
rarh7_19 an7_19 an7_20 0.45716
rarv7_19 an7_19 an8_19 0.012854
rarh7_20 an7_20 an7_21 13.526
rarv7_20 an7_20 an8_20 0.45196
rarv7_21 an7_21 an8_21 1.6401
rarh8_0 an8_0 an8_1 0.18978
rarv8_0 an8_0 an9_0 28
rarh8_1 an8_1 an8_2 0.019762
rarv8_1 an8_1 an9_1 2.9465
rarh8_2 an8_2 an8_3 0.019322
rarv8_2 an8_2 an9_2 0.24656
rarh8_3 an8_3 an8_4 0.081712
rarv8_3 an8_3 an9_3 0.11402
rarh8_4 an8_4 an8_5 0.16974
rarv8_4 an8_4 an9_4 76.296
rarh8_5 an8_5 an8_6 86.831
rarv8_5 an8_5 an9_5 23.337
rarh8_6 an8_6 an8_7 45.065
rarv8_6 an8_6 an9_6 0.012011
rarh8_7 an8_7 an8_8 30.255
rarv8_7 an8_7 an9_7 0.026531
rarh8_8 an8_8 an8_9 60.089
rarv8_8 an8_8 an9_8 2.717
rarh8_9 an8_9 an8_10 49.3
rarv8_9 an8_9 an9_9 0.042969
rarh8_10 an8_10 an8_11 5.8846
rarv8_10 an8_10 an9_10 0.016633
rarh8_11 an8_11 an8_12 10.579
rarv8_11 an8_11 an9_11 0.027153
rarh8_12 an8_12 an8_13 0.52587
rarv8_12 an8_12 an9_12 5.0432
rarh8_13 an8_13 an8_14 0.021393
rarv8_13 an8_13 an9_13 0.15694
rarh8_14 an8_14 an8_15 0.056522
rarv8_14 an8_14 an9_14 0.057144
rarh8_15 an8_15 an8_16 1.2492
rarv8_15 an8_15 an9_15 0.021173
rarh8_16 an8_16 an8_17 86.665
rarv8_16 an8_16 an9_16 0.014018
rarh8_17 an8_17 an8_18 0.53852
rarv8_17 an8_17 an9_17 1.6931
rarh8_18 an8_18 an8_19 0.015522
rarv8_18 an8_18 an9_18 0.064091
rarh8_19 an8_19 an8_20 47.913
rarv8_19 an8_19 an9_19 12.003
rarh8_20 an8_20 an8_21 69.14
rarv8_20 an8_20 an9_20 0.019354
rarv8_21 an8_21 an9_21 70.289
rarh9_0 an9_0 an9_1 0.037657
rarv9_0 an9_0 an10_0 0.011899
rarh9_1 an9_1 an9_2 68.636
rarv9_1 an9_1 an10_1 0.010146
rarh9_2 an9_2 an9_3 36.579
rarv9_2 an9_2 an10_2 0.087712
rarh9_3 an9_3 an9_4 0.24812
rarv9_3 an9_3 an10_3 4.0003
rarh9_4 an9_4 an9_5 0.6411
rarv9_4 an9_4 an10_4 0.24967
rarh9_5 an9_5 an9_6 0.13597
rarv9_5 an9_5 an10_5 0.30713
rarh9_6 an9_6 an9_7 0.33231
rarv9_6 an9_6 an10_6 12.937
rarh9_7 an9_7 an9_8 0.02877
rarv9_7 an9_7 an10_7 1.7902
rarh9_8 an9_8 an9_9 0.037947
rarv9_8 an9_8 an10_8 0.16194
rarh9_9 an9_9 an9_10 0.48947
rarv9_9 an9_9 an10_9 0.016513
rarh9_10 an9_10 an9_11 0.025579
rarv9_10 an9_10 an10_10 2.3882
rarh9_11 an9_11 an9_12 62.779
rarv9_11 an9_11 an10_11 0.092934
rarh9_12 an9_12 an9_13 0.092593
rarv9_12 an9_12 an10_12 2.1705
rarh9_13 an9_13 an9_14 1.824
rarv9_13 an9_13 an10_13 3.1857
rarh9_14 an9_14 an9_15 2.2657
rarv9_14 an9_14 an10_14 0.30124
rarh9_15 an9_15 an9_16 33.562
rarv9_15 an9_15 an10_15 5.3346
rarh9_16 an9_16 an9_17 76.59
rarv9_16 an9_16 an10_16 0.38294
rarh9_17 an9_17 an9_18 10.855
rarv9_17 an9_17 an10_17 0.049634
rarh9_18 an9_18 an9_19 1.7504
rarv9_18 an9_18 an10_18 0.068466
rarh9_19 an9_19 an9_20 0.058177
rarv9_19 an9_19 an10_19 2.9708
rarh9_20 an9_20 an9_21 10.85
rarv9_20 an9_20 an10_20 2.6414
rarv9_21 an9_21 an10_21 10.029
rarh10_0 an10_0 an10_1 89.715
rarv10_0 an10_0 an11_0 1.2959
rarh10_1 an10_1 an10_2 6.6347
rarv10_1 an10_1 an11_1 12.851
rarh10_2 an10_2 an10_3 11.756
rarv10_2 an10_2 an11_2 9.6522
rarh10_3 an10_3 an10_4 8.3217
rarv10_3 an10_3 an11_3 0.028322
rarh10_4 an10_4 an10_5 46.974
rarv10_4 an10_4 an11_4 0.014447
rarh10_5 an10_5 an10_6 6.8916
rarv10_5 an10_5 an11_5 85.05
rarh10_6 an10_6 an10_7 0.19606
rarv10_6 an10_6 an11_6 0.01041
rarh10_7 an10_7 an10_8 0.070847
rarv10_7 an10_7 an11_7 0.04512
rarh10_8 an10_8 an10_9 0.021327
rarv10_8 an10_8 an11_8 4.9031
rarh10_9 an10_9 an10_10 0.012852
rarv10_9 an10_9 an11_9 0.13062
rarh10_10 an10_10 an10_11 5.7498
rarv10_10 an10_10 an11_10 0.013581
rarh10_11 an10_11 an10_12 7.7532
rarv10_11 an10_11 an11_11 76.953
rarh10_12 an10_12 an10_13 8.1451
rarv10_12 an10_12 an11_12 0.032028
rarh10_13 an10_13 an10_14 0.081907
rarv10_13 an10_13 an11_13 3.5273
rarh10_14 an10_14 an10_15 0.75035
rarv10_14 an10_14 an11_14 0.011616
rarh10_15 an10_15 an10_16 3.5379
rarv10_15 an10_15 an11_15 0.030288
rarh10_16 an10_16 an10_17 0.18264
rarv10_16 an10_16 an11_16 0.081921
rarh10_17 an10_17 an10_18 40.984
rarv10_17 an10_17 an11_17 73.659
rarh10_18 an10_18 an10_19 0.36118
rarv10_18 an10_18 an11_18 0.51524
rarh10_19 an10_19 an10_20 0.4518
rarv10_19 an10_19 an11_19 38.747
rarh10_20 an10_20 an10_21 11.446
rarv10_20 an10_20 an11_20 0.029769
rarv10_21 an10_21 an11_21 0.21627
rarh11_0 an11_0 an11_1 0.4376
rarv11_0 an11_0 an12_0 32.465
rarh11_1 an11_1 an11_2 0.64741
rarv11_1 an11_1 an12_1 38.728
rarh11_2 an11_2 an11_3 0.12581
rarv11_2 an11_2 an12_2 35.427
rarh11_3 an11_3 an11_4 0.93395
rarv11_3 an11_3 an12_3 92.382
rarh11_4 an11_4 an11_5 49.931
rarv11_4 an11_4 an12_4 0.050761
rarh11_5 an11_5 an11_6 0.094384
rarv11_5 an11_5 an12_5 0.44967
rarh11_6 an11_6 an11_7 2.6361
rarv11_6 an11_6 an12_6 0.88625
rarh11_7 an11_7 an11_8 3.78
rarv11_7 an11_7 an12_7 0.72062
rarh11_8 an11_8 an11_9 13.661
rarv11_8 an11_8 an12_8 0.021202
rarh11_9 an11_9 an11_10 0.19401
rarv11_9 an11_9 an12_9 55.56
rarh11_10 an11_10 an11_11 10.132
rarv11_10 an11_10 an12_10 1.6738
rarh11_11 an11_11 an11_12 22.573
rarv11_11 an11_11 an12_11 27.079
rarh11_12 an11_12 an11_13 2.0331
rarv11_12 an11_12 an12_12 0.1529
rarh11_13 an11_13 an11_14 0.1319
rarv11_13 an11_13 an12_13 10.047
rarh11_14 an11_14 an11_15 0.936
rarv11_14 an11_14 an12_14 0.043377
rarh11_15 an11_15 an11_16 7.8282
rarv11_15 an11_15 an12_15 0.17466
rarh11_16 an11_16 an11_17 5.1896
rarv11_16 an11_16 an12_16 0.016062
rarh11_17 an11_17 an11_18 3.4088
rarv11_17 an11_17 an12_17 2.8552
rarh11_18 an11_18 an11_19 0.033206
rarv11_18 an11_18 an12_18 16.883
rarh11_19 an11_19 an11_20 43.057
rarv11_19 an11_19 an12_19 1.8508
rarh11_20 an11_20 an11_21 2.3375
rarv11_20 an11_20 an12_20 1.2772
rarv11_21 an11_21 an12_21 0.018238
rarh12_0 an12_0 an12_1 0.022209
rarv12_0 an12_0 an13_0 0.17594
rarh12_1 an12_1 an12_2 0.10643
rarv12_1 an12_1 an13_1 0.21395
rarh12_2 an12_2 an12_3 36.801
rarv12_2 an12_2 an13_2 0.47588
rarh12_3 an12_3 an12_4 0.025856
rarv12_3 an12_3 an13_3 0.71022
rarh12_4 an12_4 an12_5 2.2596
rarv12_4 an12_4 an13_4 96.307
rarh12_5 an12_5 an12_6 1.1732
rarv12_5 an12_5 an13_5 65.869
rarh12_6 an12_6 an12_7 14.797
rarv12_6 an12_6 an13_6 0.012802
rarh12_7 an12_7 an12_8 52.513
rarv12_7 an12_7 an13_7 0.012495
rarh12_8 an12_8 an12_9 32.679
rarv12_8 an12_8 an13_8 0.018837
rarh12_9 an12_9 an12_10 22.988
rarv12_9 an12_9 an13_9 0.80923
rarh12_10 an12_10 an12_11 0.78246
rarv12_10 an12_10 an13_10 0.16827
rarh12_11 an12_11 an12_12 19.646
rarv12_11 an12_11 an13_11 0.013998
rarh12_12 an12_12 an12_13 0.21072
rarv12_12 an12_12 an13_12 0.74406
rarh12_13 an12_13 an12_14 24.763
rarv12_13 an12_13 an13_13 0.36897
rarh12_14 an12_14 an12_15 0.16019
rarv12_14 an12_14 an13_14 1.5729
rarh12_15 an12_15 an12_16 0.081719
rarv12_15 an12_15 an13_15 1.002
rarh12_16 an12_16 an12_17 3.3612
rarv12_16 an12_16 an13_16 0.040295
rarh12_17 an12_17 an12_18 3.2454
rarv12_17 an12_17 an13_17 76.096
rarh12_18 an12_18 an12_19 8.5164
rarv12_18 an12_18 an13_18 6.2662
rarh12_19 an12_19 an12_20 1.1299
rarv12_19 an12_19 an13_19 0.74627
rarh12_20 an12_20 an12_21 57.7
rarv12_20 an12_20 an13_20 3.7508
rarv12_21 an12_21 an13_21 0.56683
rarh13_0 an13_0 an13_1 60.786
rarv13_0 an13_0 an14_0 0.034466
rarh13_1 an13_1 an13_2 7.7366
rarv13_1 an13_1 an14_1 5.733
rarh13_2 an13_2 an13_3 3.7983
rarv13_2 an13_2 an14_2 5.6392
rarh13_3 an13_3 an13_4 28.539
rarv13_3 an13_3 an14_3 1.1959
rarh13_4 an13_4 an13_5 0.12794
rarv13_4 an13_4 an14_4 0.18351
rarh13_5 an13_5 an13_6 0.10368
rarv13_5 an13_5 an14_5 2.6404
rarh13_6 an13_6 an13_7 0.42065
rarv13_6 an13_6 an14_6 32.205
rarh13_7 an13_7 an13_8 0.014
rarv13_7 an13_7 an14_7 0.056695
rarh13_8 an13_8 an13_9 0.25379
rarv13_8 an13_8 an14_8 0.15996
rarh13_9 an13_9 an13_10 0.73884
rarv13_9 an13_9 an14_9 2.5481
rarh13_10 an13_10 an13_11 0.91974
rarv13_10 an13_10 an14_10 0.62071
rarh13_11 an13_11 an13_12 0.011752
rarv13_11 an13_11 an14_11 0.010543
rarh13_12 an13_12 an13_13 0.32596
rarv13_12 an13_12 an14_12 80.324
rarh13_13 an13_13 an13_14 0.35207
rarv13_13 an13_13 an14_13 0.42935
rarh13_14 an13_14 an13_15 0.053754
rarv13_14 an13_14 an14_14 2.4196
rarh13_15 an13_15 an13_16 0.037917
rarv13_15 an13_15 an14_15 1.6089
rarh13_16 an13_16 an13_17 0.55176
rarv13_16 an13_16 an14_16 0.055745
rarh13_17 an13_17 an13_18 0.095412
rarv13_17 an13_17 an14_17 3.6819
rarh13_18 an13_18 an13_19 0.33148
rarv13_18 an13_18 an14_18 0.030714
rarh13_19 an13_19 an13_20 44.442
rarv13_19 an13_19 an14_19 88.966
rarh13_20 an13_20 an13_21 26.064
rarv13_20 an13_20 an14_20 3.1928
rarv13_21 an13_21 an14_21 0.02761
rarh14_0 an14_0 an14_1 0.28799
rarv14_0 an14_0 an15_0 0.19308
rarh14_1 an14_1 an14_2 2.6396
rarv14_1 an14_1 an15_1 0.14575
rarh14_2 an14_2 an14_3 0.29946
rarv14_2 an14_2 an15_2 1.9543
rarh14_3 an14_3 an14_4 0.09652
rarv14_3 an14_3 an15_3 57.22
rarh14_4 an14_4 an14_5 32.451
rarv14_4 an14_4 an15_4 48.798
rarh14_5 an14_5 an14_6 8.7874
rarv14_5 an14_5 an15_5 0.01095
rarh14_6 an14_6 an14_7 14.28
rarv14_6 an14_6 an15_6 4.4055
rarh14_7 an14_7 an14_8 37.396
rarv14_7 an14_7 an15_7 6.531
rarh14_8 an14_8 an14_9 18.645
rarv14_8 an14_8 an15_8 62.476
rarh14_9 an14_9 an14_10 6.9985
rarv14_9 an14_9 an15_9 21.725
rarh14_10 an14_10 an14_11 19.867
rarv14_10 an14_10 an15_10 82.302
rarh14_11 an14_11 an14_12 0.80469
rarv14_11 an14_11 an15_11 39.431
rarh14_12 an14_12 an14_13 0.13877
rarv14_12 an14_12 an15_12 24.392
rarh14_13 an14_13 an14_14 2.1861
rarv14_13 an14_13 an15_13 1.4616
rarh14_14 an14_14 an14_15 0.046352
rarv14_14 an14_14 an15_14 2.0511
rarh14_15 an14_15 an14_16 4.1102
rarv14_15 an14_15 an15_15 1.79
rarh14_16 an14_16 an14_17 29.144
rarv14_16 an14_16 an15_16 0.3955
rarh14_17 an14_17 an14_18 0.013147
rarv14_17 an14_17 an15_17 0.19565
rarh14_18 an14_18 an14_19 0.032432
rarv14_18 an14_18 an15_18 8.2061
rarh14_19 an14_19 an14_20 0.012133
rarv14_19 an14_19 an15_19 6.893
rarh14_20 an14_20 an14_21 3.5575
rarv14_20 an14_20 an15_20 4.0947
rarv14_21 an14_21 an15_21 0.66479
rarh15_0 an15_0 an15_1 3.088
rarv15_0 an15_0 an16_0 0.10379
rarh15_1 an15_1 an15_2 0.041186
rarv15_1 an15_1 an16_1 13.133
rarh15_2 an15_2 an15_3 0.13033
rarv15_2 an15_2 an16_2 0.49175
rarh15_3 an15_3 an15_4 1.9923
rarv15_3 an15_3 an16_3 0.018405
rarh15_4 an15_4 an15_5 0.069036
rarv15_4 an15_4 an16_4 0.34543
rarh15_5 an15_5 an15_6 0.072768
rarv15_5 an15_5 an16_5 5.9813
rarh15_6 an15_6 an15_7 37.105
rarv15_6 an15_6 an16_6 2.2721
rarh15_7 an15_7 an15_8 83.341
rarv15_7 an15_7 an16_7 0.022309
rarh15_8 an15_8 an15_9 2.8302
rarv15_8 an15_8 an16_8 2.1074
rarh15_9 an15_9 an15_10 27.063
rarv15_9 an15_9 an16_9 0.61585
rarh15_10 an15_10 an15_11 0.96513
rarv15_10 an15_10 an16_10 0.011365
rarh15_11 an15_11 an15_12 6.392
rarv15_11 an15_11 an16_11 16.312
rarh15_12 an15_12 an15_13 1.1577
rarv15_12 an15_12 an16_12 28.237
rarh15_13 an15_13 an15_14 1.6716
rarv15_13 an15_13 an16_13 46.113
rarh15_14 an15_14 an15_15 0.018684
rarv15_14 an15_14 an16_14 0.37943
rarh15_15 an15_15 an15_16 11.504
rarv15_15 an15_15 an16_15 0.51207
rarh15_16 an15_16 an15_17 2.041
rarv15_16 an15_16 an16_16 0.016679
rarh15_17 an15_17 an15_18 0.12387
rarv15_17 an15_17 an16_17 20.019
rarh15_18 an15_18 an15_19 0.53111
rarv15_18 an15_18 an16_18 0.11321
rarh15_19 an15_19 an15_20 2.9985
rarv15_19 an15_19 an16_19 0.18716
rarh15_20 an15_20 an15_21 81.044
rarv15_20 an15_20 an16_20 16.754
rarv15_21 an15_21 an16_21 0.19383
rarh16_0 an16_0 an16_1 0.14553
rarv16_0 an16_0 an17_0 0.25127
rarh16_1 an16_1 an16_2 2.126
rarv16_1 an16_1 an17_1 0.26332
rarh16_2 an16_2 an16_3 40.257
rarv16_2 an16_2 an17_2 38.679
rarh16_3 an16_3 an16_4 15.618
rarv16_3 an16_3 an17_3 24.155
rarh16_4 an16_4 an16_5 2.6809
rarv16_4 an16_4 an17_4 0.7507
rarh16_5 an16_5 an16_6 0.092602
rarv16_5 an16_5 an17_5 0.57702
rarh16_6 an16_6 an16_7 0.89986
rarv16_6 an16_6 an17_6 4.4468
rarh16_7 an16_7 an16_8 0.011547
rarv16_7 an16_7 an17_7 65.22
rarh16_8 an16_8 an16_9 0.56118
rarv16_8 an16_8 an17_8 0.076466
rarh16_9 an16_9 an16_10 0.26213
rarv16_9 an16_9 an17_9 0.75643
rarh16_10 an16_10 an16_11 0.020835
rarv16_10 an16_10 an17_10 0.73866
rarh16_11 an16_11 an16_12 0.015975
rarv16_11 an16_11 an17_11 24.352
rarh16_12 an16_12 an16_13 0.018113
rarv16_12 an16_12 an17_12 0.13993
rarh16_13 an16_13 an16_14 0.028306
rarv16_13 an16_13 an17_13 0.022343
rarh16_14 an16_14 an16_15 3.6791
rarv16_14 an16_14 an17_14 0.1211
rarh16_15 an16_15 an16_16 2.3388
rarv16_15 an16_15 an17_15 25.679
rarh16_16 an16_16 an16_17 0.02121
rarv16_16 an16_16 an17_16 0.030382
rarh16_17 an16_17 an16_18 1.5384
rarv16_17 an16_17 an17_17 0.1474
rarh16_18 an16_18 an16_19 0.76392
rarv16_18 an16_18 an17_18 0.059424
rarh16_19 an16_19 an16_20 25.688
rarv16_19 an16_19 an17_19 0.92226
rarh16_20 an16_20 an16_21 0.74295
rarv16_20 an16_20 an17_20 3.086
rarv16_21 an16_21 an17_21 0.19857
rarh17_0 an17_0 an17_1 26.089
rarv17_0 an17_0 an18_0 1.0646
rarh17_1 an17_1 an17_2 30.062
rarv17_1 an17_1 an18_1 0.96719
rarh17_2 an17_2 an17_3 0.35974
rarv17_2 an17_2 an18_2 0.17956
rarh17_3 an17_3 an17_4 38.06
rarv17_3 an17_3 an18_3 0.63562
rarh17_4 an17_4 an17_5 72.881
rarv17_4 an17_4 an18_4 0.040853
rarh17_5 an17_5 an17_6 0.013455
rarv17_5 an17_5 an18_5 0.063698
rarh17_6 an17_6 an17_7 1.5303
rarv17_6 an17_6 an18_6 69.104
rarh17_7 an17_7 an17_8 88.285
rarv17_7 an17_7 an18_7 0.29406
rarh17_8 an17_8 an17_9 45.847
rarv17_8 an17_8 an18_8 0.15453
rarh17_9 an17_9 an17_10 79.987
rarv17_9 an17_9 an18_9 0.26918
rarh17_10 an17_10 an17_11 0.26713
rarv17_10 an17_10 an18_10 0.031844
rarh17_11 an17_11 an17_12 0.17586
rarv17_11 an17_11 an18_11 0.18298
rarh17_12 an17_12 an17_13 0.7229
rarv17_12 an17_12 an18_12 3.6166
rarh17_13 an17_13 an17_14 4.3613
rarv17_13 an17_13 an18_13 0.31353
rarh17_14 an17_14 an17_15 1.4887
rarv17_14 an17_14 an18_14 8.0976
rarh17_15 an17_15 an17_16 0.29057
rarv17_15 an17_15 an18_15 1.1484
rarh17_16 an17_16 an17_17 0.28407
rarv17_16 an17_16 an18_16 0.030149
rarh17_17 an17_17 an17_18 2.072
rarv17_17 an17_17 an18_17 0.023885
rarh17_18 an17_18 an17_19 84.05
rarv17_18 an17_18 an18_18 0.01294
rarh17_19 an17_19 an17_20 1.1397
rarv17_19 an17_19 an18_19 1.3848
rarh17_20 an17_20 an17_21 1.9116
rarv17_20 an17_20 an18_20 2.016
rarv17_21 an17_21 an18_21 0.029814
rarh18_0 an18_0 an18_1 1.272
rarv18_0 an18_0 an19_0 65.628
rarh18_1 an18_1 an18_2 1.4798
rarv18_1 an18_1 an19_1 44.141
rarh18_2 an18_2 an18_3 0.40894
rarv18_2 an18_2 an19_2 0.014347
rarh18_3 an18_3 an18_4 0.061888
rarv18_3 an18_3 an19_3 16.409
rarh18_4 an18_4 an18_5 0.51091
rarv18_4 an18_4 an19_4 0.27205
rarh18_5 an18_5 an18_6 0.068644
rarv18_5 an18_5 an19_5 1.6279
rarh18_6 an18_6 an18_7 0.039196
rarv18_6 an18_6 an19_6 0.029747
rarh18_7 an18_7 an18_8 38.273
rarv18_7 an18_7 an19_7 0.92358
rarh18_8 an18_8 an18_9 49.525
rarv18_8 an18_8 an19_8 1.4933
rarh18_9 an18_9 an18_10 0.64314
rarv18_9 an18_9 an19_9 0.11604
rarh18_10 an18_10 an18_11 30.908
rarv18_10 an18_10 an19_10 0.02018
rarh18_11 an18_11 an18_12 2.2793
rarv18_11 an18_11 an19_11 12.75
rarh18_12 an18_12 an18_13 9.7473
rarv18_12 an18_12 an19_12 0.62111
rarh18_13 an18_13 an18_14 0.035547
rarv18_13 an18_13 an19_13 0.016576
rarh18_14 an18_14 an18_15 1.6198
rarv18_14 an18_14 an19_14 0.047372
rarh18_15 an18_15 an18_16 5.9411
rarv18_15 an18_15 an19_15 0.28266
rarh18_16 an18_16 an18_17 0.043261
rarv18_16 an18_16 an19_16 23.663
rarh18_17 an18_17 an18_18 7.7821
rarv18_17 an18_17 an19_17 0.24854
rarh18_18 an18_18 an18_19 0.35084
rarv18_18 an18_18 an19_18 1.4105
rarh18_19 an18_19 an18_20 0.7143
rarv18_19 an18_19 an19_19 0.046045
rarh18_20 an18_20 an18_21 0.016931
rarv18_20 an18_20 an19_20 0.26183
rarv18_21 an18_21 an19_21 0.34735
rarh19_0 an19_0 an19_1 0.13413
rarv19_0 an19_0 an20_0 39.031
rarh19_1 an19_1 an19_2 62.609
rarv19_1 an19_1 an20_1 0.568
rarh19_2 an19_2 an19_3 0.85164
rarv19_2 an19_2 an20_2 19.501
rarh19_3 an19_3 an19_4 3.0974
rarv19_3 an19_3 an20_3 46.255
rarh19_4 an19_4 an19_5 2.0139
rarv19_4 an19_4 an20_4 27.721
rarh19_5 an19_5 an19_6 44.892
rarv19_5 an19_5 an20_5 0.68149
rarh19_6 an19_6 an19_7 0.022886
rarv19_6 an19_6 an20_6 0.36386
rarh19_7 an19_7 an19_8 0.22514
rarv19_7 an19_7 an20_7 49.831
rarh19_8 an19_8 an19_9 1.8627
rarv19_8 an19_8 an20_8 0.65547
rarh19_9 an19_9 an19_10 0.18912
rarv19_9 an19_9 an20_9 0.84976
rarh19_10 an19_10 an19_11 6.0006
rarv19_10 an19_10 an20_10 28.601
rarh19_11 an19_11 an19_12 4.5593
rarv19_11 an19_11 an20_11 0.036837
rarh19_12 an19_12 an19_13 0.30798
rarv19_12 an19_12 an20_12 1.0266
rarh19_13 an19_13 an19_14 0.028251
rarv19_13 an19_13 an20_13 35.888
rarh19_14 an19_14 an19_15 1.0322
rarv19_14 an19_14 an20_14 14.578
rarh19_15 an19_15 an19_16 10.072
rarv19_15 an19_15 an20_15 12.278
rarh19_16 an19_16 an19_17 0.040303
rarv19_16 an19_16 an20_16 0.37718
rarh19_17 an19_17 an19_18 0.29454
rarv19_17 an19_17 an20_17 0.77113
rarh19_18 an19_18 an19_19 0.019908
rarv19_18 an19_18 an20_18 8.3733
rarh19_19 an19_19 an19_20 0.1412
rarv19_19 an19_19 an20_19 28.17
rarh19_20 an19_20 an19_21 18.495
rarv19_20 an19_20 an20_20 5.9805
rarv19_21 an19_21 an20_21 87.024
rarh20_0 an20_0 an20_1 0.039848
rarv20_0 an20_0 an21_0 62.412
rarh20_1 an20_1 an20_2 0.022554
rarv20_1 an20_1 an21_1 0.05519
rarh20_2 an20_2 an20_3 0.91308
rarv20_2 an20_2 an21_2 0.12149
rarh20_3 an20_3 an20_4 0.65365
rarv20_3 an20_3 an21_3 0.062637
rarh20_4 an20_4 an20_5 0.28101
rarv20_4 an20_4 an21_4 0.014571
rarh20_5 an20_5 an20_6 0.024432
rarv20_5 an20_5 an21_5 6.5893
rarh20_6 an20_6 an20_7 0.68363
rarv20_6 an20_6 an21_6 10.852
rarh20_7 an20_7 an20_8 2.7288
rarv20_7 an20_7 an21_7 67.534
rarh20_8 an20_8 an20_9 0.55671
rarv20_8 an20_8 an21_8 2.036
rarh20_9 an20_9 an20_10 0.0797
rarv20_9 an20_9 an21_9 44.03
rarh20_10 an20_10 an20_11 0.029079
rarv20_10 an20_10 an21_10 51.95
rarh20_11 an20_11 an20_12 0.013697
rarv20_11 an20_11 an21_11 5.2514
rarh20_12 an20_12 an20_13 5.1019
rarv20_12 an20_12 an21_12 1.2833
rarh20_13 an20_13 an20_14 3.8802
rarv20_13 an20_13 an21_13 0.022293
rarh20_14 an20_14 an20_15 7.8705
rarv20_14 an20_14 an21_14 0.42301
rarh20_15 an20_15 an20_16 8.7201
rarv20_15 an20_15 an21_15 0.046761
rarh20_16 an20_16 an20_17 50.796
rarv20_16 an20_16 an21_16 0.42332
rarh20_17 an20_17 an20_18 0.29557
rarv20_17 an20_17 an21_17 3.6366
rarh20_18 an20_18 an20_19 2.5958
rarv20_18 an20_18 an21_18 22.279
rarh20_19 an20_19 an20_20 0.046121
rarv20_19 an20_19 an21_19 0.036349
rarh20_20 an20_20 an20_21 5.7006
rarv20_20 an20_20 an21_20 2.1644
rarv20_21 an20_21 an21_21 0.14511
rarh21_0 an21_0 an21_1 0.044466
rarh21_1 an21_1 an21_2 0.011544
rarh21_2 an21_2 an21_3 0.3283
rarh21_3 an21_3 an21_4 0.010761
rarh21_4 an21_4 an21_5 0.3853
rarh21_5 an21_5 an21_6 2.0096
rarh21_6 an21_6 an21_7 0.047863
rarh21_7 an21_7 an21_8 6.4954
rarh21_8 an21_8 an21_9 0.021558
rarh21_9 an21_9 an21_10 3.3955
rarh21_10 an21_10 an21_11 0.73929
rarh21_11 an21_11 an21_12 0.010796
rarh21_12 an21_12 an21_13 2.3408
rarh21_13 an21_13 an21_14 6.763
rarh21_14 an21_14 an21_15 0.28986
rarh21_15 an21_15 an21_16 7.6391
rarh21_16 an21_16 an21_17 56.591
rarh21_17 an21_17 an21_18 26.955
rarh21_18 an21_18 an21_19 43.674
rarh21_19 an21_19 an21_20 0.05288
rarh21_20 an21_20 an21_21 0.011858
rap0 ap1 an0_0 0.01
rap1 an0_21 0 0.01
rap2 an21_0 0 0.01
rap3 ap2 an21_21 0.01
va1 ap1 0 DC 1.0
va2 ap2 0 DC 0
ia3 0 an11_7 DC 0
rbrh0_0 bn0_0 bn0_1 0.07949
rbrv0_0 bn0_0 bn1_0 0.043191
rbrh0_1 bn0_1 bn0_2 0.028901
rbrv0_1 bn0_1 bn1_1 0.77446
rbrh0_2 bn0_2 bn0_3 2.1612
rbrv0_2 bn0_2 bn1_2 0.05834
rbrh0_3 bn0_3 bn0_4 0.16298
rbrv0_3 bn0_3 bn1_3 21.178
rbrh0_4 bn0_4 bn0_5 5.4182
rbrv0_4 bn0_4 bn1_4 2.4593
rbrh0_5 bn0_5 bn0_6 0.46846
rbrv0_5 bn0_5 bn1_5 4.968
rbrh0_6 bn0_6 bn0_7 0.02753
rbrv0_6 bn0_6 bn1_6 0.13939
rbrh0_7 bn0_7 bn0_8 6.0318
rbrv0_7 bn0_7 bn1_7 60.963
rbrh0_8 bn0_8 bn0_9 0.21165
rbrv0_8 bn0_8 bn1_8 1.6668
rbrh0_9 bn0_9 bn0_10 0.010995
rbrv0_9 bn0_9 bn1_9 0.023165
rbrh0_10 bn0_10 bn0_11 16.849
rbrv0_10 bn0_10 bn1_10 10.344
rbrh0_11 bn0_11 bn0_12 2.5996
rbrv0_11 bn0_11 bn1_11 3.9229
rbrh0_12 bn0_12 bn0_13 0.011808
rbrv0_12 bn0_12 bn1_12 0.19891
rbrh0_13 bn0_13 bn0_14 34.492
rbrv0_13 bn0_13 bn1_13 13.64
rbrh0_14 bn0_14 bn0_15 0.024922
rbrv0_14 bn0_14 bn1_14 0.13267
rbrh0_15 bn0_15 bn0_16 0.40219
rbrv0_15 bn0_15 bn1_15 1.7994
rbrh0_16 bn0_16 bn0_17 0.26296
rbrv0_16 bn0_16 bn1_16 0.38977
rbrh0_17 bn0_17 bn0_18 1.202
rbrv0_17 bn0_17 bn1_17 0.30597
rbrh0_18 bn0_18 bn0_19 0.23269
rbrv0_18 bn0_18 bn1_18 0.031318
rbrh0_19 bn0_19 bn0_20 1.0647
rbrv0_19 bn0_19 bn1_19 6.0872
rbrh0_20 bn0_20 bn0_21 0.25332
rbrv0_20 bn0_20 bn1_20 3.5917
rbrv0_21 bn0_21 bn1_21 0.85048
rbrh1_0 bn1_0 bn1_1 0.6922
rbrv1_0 bn1_0 bn2_0 45.621
rbrh1_1 bn1_1 bn1_2 0.71431
rbrv1_1 bn1_1 bn2_1 0.13417
rbrh1_2 bn1_2 bn1_3 0.013207
rbrv1_2 bn1_2 bn2_2 0.54203
rbrh1_3 bn1_3 bn1_4 5.5036
rbrv1_3 bn1_3 bn2_3 5.0865
rbrh1_4 bn1_4 bn1_5 10.943
rbrv1_4 bn1_4 bn2_4 1.2935
rbrh1_5 bn1_5 bn1_6 34.522
rbrv1_5 bn1_5 bn2_5 0.13683
rbrh1_6 bn1_6 bn1_7 0.14296
rbrv1_6 bn1_6 bn2_6 0.020727
rbrh1_7 bn1_7 bn1_8 0.29661
rbrv1_7 bn1_7 bn2_7 69.16
rbrh1_8 bn1_8 bn1_9 0.013871
rbrv1_8 bn1_8 bn2_8 0.38808
rbrh1_9 bn1_9 bn1_10 0.72185
rbrv1_9 bn1_9 bn2_9 82.573
rbrh1_10 bn1_10 bn1_11 0.016368
rbrv1_10 bn1_10 bn2_10 34.725
rbrh1_11 bn1_11 bn1_12 15.726
rbrv1_11 bn1_11 bn2_11 40.729
rbrh1_12 bn1_12 bn1_13 0.1815
rbrv1_12 bn1_12 bn2_12 0.339
rbrh1_13 bn1_13 bn1_14 80.753
rbrv1_13 bn1_13 bn2_13 0.17824
rbrh1_14 bn1_14 bn1_15 0.015231
rbrv1_14 bn1_14 bn2_14 0.26242
rbrh1_15 bn1_15 bn1_16 2.1893
rbrv1_15 bn1_15 bn2_15 0.039898
rbrh1_16 bn1_16 bn1_17 65.903
rbrv1_16 bn1_16 bn2_16 6.0463
rbrh1_17 bn1_17 bn1_18 1.712
rbrv1_17 bn1_17 bn2_17 7.8001
rbrh1_18 bn1_18 bn1_19 0.41694
rbrv1_18 bn1_18 bn2_18 1.8557
rbrh1_19 bn1_19 bn1_20 0.12409
rbrv1_19 bn1_19 bn2_19 68.908
rbrh1_20 bn1_20 bn1_21 0.40098
rbrv1_20 bn1_20 bn2_20 0.015704
rbrv1_21 bn1_21 bn2_21 2.9761
rbrh2_0 bn2_0 bn2_1 4.1782
rbrv2_0 bn2_0 bn3_0 32.687
rbrh2_1 bn2_1 bn2_2 10.885
rbrv2_1 bn2_1 bn3_1 92.17
rbrh2_2 bn2_2 bn2_3 0.5774
rbrv2_2 bn2_2 bn3_2 14.271
rbrh2_3 bn2_3 bn2_4 0.025447
rbrv2_3 bn2_3 bn3_3 0.011217
rbrh2_4 bn2_4 bn2_5 57.129
rbrv2_4 bn2_4 bn3_4 5.6204
rbrh2_5 bn2_5 bn2_6 12.873
rbrv2_5 bn2_5 bn3_5 66.15
rbrh2_6 bn2_6 bn2_7 4.167
rbrv2_6 bn2_6 bn3_6 29.546
rbrh2_7 bn2_7 bn2_8 11.991
rbrv2_7 bn2_7 bn3_7 0.84034
rbrh2_8 bn2_8 bn2_9 1.5378
rbrv2_8 bn2_8 bn3_8 0.77671
rbrh2_9 bn2_9 bn2_10 0.97199
rbrv2_9 bn2_9 bn3_9 0.031234
rbrh2_10 bn2_10 bn2_11 48.476
rbrv2_10 bn2_10 bn3_10 1.6643
rbrh2_11 bn2_11 bn2_12 7.9116
rbrv2_11 bn2_11 bn3_11 0.40806
rbrh2_12 bn2_12 bn2_13 0.04472
rbrv2_12 bn2_12 bn3_12 4.545
rbrh2_13 bn2_13 bn2_14 0.034361
rbrv2_13 bn2_13 bn3_13 36.836
rbrh2_14 bn2_14 bn2_15 26.16
rbrv2_14 bn2_14 bn3_14 0.20188
rbrh2_15 bn2_15 bn2_16 0.62895
rbrv2_15 bn2_15 bn3_15 2.3787
rbrh2_16 bn2_16 bn2_17 0.012442
rbrv2_16 bn2_16 bn3_16 0.019225
rbrh2_17 bn2_17 bn2_18 18.08
rbrv2_17 bn2_17 bn3_17 6.437
rbrh2_18 bn2_18 bn2_19 0.018971
rbrv2_18 bn2_18 bn3_18 0.24233
rbrh2_19 bn2_19 bn2_20 7.7019
rbrv2_19 bn2_19 bn3_19 0.17618
rbrh2_20 bn2_20 bn2_21 0.015317
rbrv2_20 bn2_20 bn3_20 1.8787
rbrv2_21 bn2_21 bn3_21 19.61
rbrh3_0 bn3_0 bn3_1 1.0689
rbrv3_0 bn3_0 bn4_0 0.2415
rbrh3_1 bn3_1 bn3_2 0.46929
rbrv3_1 bn3_1 bn4_1 0.89046
rbrh3_2 bn3_2 bn3_3 13.198
rbrv3_2 bn3_2 bn4_2 4.9925
rbrh3_3 bn3_3 bn3_4 23
rbrv3_3 bn3_3 bn4_3 0.25447
rbrh3_4 bn3_4 bn3_5 0.019077
rbrv3_4 bn3_4 bn4_4 0.040085
rbrh3_5 bn3_5 bn3_6 9.1707
rbrv3_5 bn3_5 bn4_5 36.957
rbrh3_6 bn3_6 bn3_7 36.669
rbrv3_6 bn3_6 bn4_6 3.7385
rbrh3_7 bn3_7 bn3_8 0.13621
rbrv3_7 bn3_7 bn4_7 0.37056
rbrh3_8 bn3_8 bn3_9 2.2891
rbrv3_8 bn3_8 bn4_8 35.826
rbrh3_9 bn3_9 bn3_10 63.361
rbrv3_9 bn3_9 bn4_9 38.612
rbrh3_10 bn3_10 bn3_11 29.633
rbrv3_10 bn3_10 bn4_10 0.67233
rbrh3_11 bn3_11 bn3_12 4.1311
rbrv3_11 bn3_11 bn4_11 1.4558
rbrh3_12 bn3_12 bn3_13 9.9609
rbrv3_12 bn3_12 bn4_12 1.6093
rbrh3_13 bn3_13 bn3_14 0.67203
rbrv3_13 bn3_13 bn4_13 6.2123
rbrh3_14 bn3_14 bn3_15 40.961
rbrv3_14 bn3_14 bn4_14 9.9189
rbrh3_15 bn3_15 bn3_16 0.022801
rbrv3_15 bn3_15 bn4_15 7.8165
rbrh3_16 bn3_16 bn3_17 0.20934
rbrv3_16 bn3_16 bn4_16 0.36185
rbrh3_17 bn3_17 bn3_18 0.030169
rbrv3_17 bn3_17 bn4_17 0.39251
rbrh3_18 bn3_18 bn3_19 0.02581
rbrv3_18 bn3_18 bn4_18 3.5432
rbrh3_19 bn3_19 bn3_20 5.7127
rbrv3_19 bn3_19 bn4_19 24.462
rbrh3_20 bn3_20 bn3_21 0.47624
rbrv3_20 bn3_20 bn4_20 1.2544
rbrv3_21 bn3_21 bn4_21 0.015166
rbrh4_0 bn4_0 bn4_1 15.202
rbrv4_0 bn4_0 bn5_0 1.0369
rbrh4_1 bn4_1 bn4_2 68.81
rbrv4_1 bn4_1 bn5_1 3.4048
rbrh4_2 bn4_2 bn4_3 15.495
rbrv4_2 bn4_2 bn5_2 0.6625
rbrh4_3 bn4_3 bn4_4 0.35928
rbrv4_3 bn4_3 bn5_3 0.20089
rbrh4_4 bn4_4 bn4_5 38.517
rbrv4_4 bn4_4 bn5_4 41.402
rbrh4_5 bn4_5 bn4_6 0.010792
rbrv4_5 bn4_5 bn5_5 3.86
rbrh4_6 bn4_6 bn4_7 0.63189
rbrv4_6 bn4_6 bn5_6 35.075
rbrh4_7 bn4_7 bn4_8 25.152
rbrv4_7 bn4_7 bn5_7 0.41562
rbrh4_8 bn4_8 bn4_9 31.334
rbrv4_8 bn4_8 bn5_8 0.075579
rbrh4_9 bn4_9 bn4_10 76
rbrv4_9 bn4_9 bn5_9 0.32575
rbrh4_10 bn4_10 bn4_11 2.6932
rbrv4_10 bn4_10 bn5_10 54.979
rbrh4_11 bn4_11 bn4_12 0.36634
rbrv4_11 bn4_11 bn5_11 55.475
rbrh4_12 bn4_12 bn4_13 5.7295
rbrv4_12 bn4_12 bn5_12 0.13068
rbrh4_13 bn4_13 bn4_14 8.8078
rbrv4_13 bn4_13 bn5_13 0.65371
rbrh4_14 bn4_14 bn4_15 0.015192
rbrv4_14 bn4_14 bn5_14 0.015676
rbrh4_15 bn4_15 bn4_16 0.013824
rbrv4_15 bn4_15 bn5_15 5.5302
rbrh4_16 bn4_16 bn4_17 0.073462
rbrv4_16 bn4_16 bn5_16 0.1036
rbrh4_17 bn4_17 bn4_18 0.45409
rbrv4_17 bn4_17 bn5_17 0.074468
rbrh4_18 bn4_18 bn4_19 0.18253
rbrv4_18 bn4_18 bn5_18 0.247
rbrh4_19 bn4_19 bn4_20 0.12481
rbrv4_19 bn4_19 bn5_19 10.966
rbrh4_20 bn4_20 bn4_21 0.072396
rbrv4_20 bn4_20 bn5_20 72.642
rbrv4_21 bn4_21 bn5_21 0.10097
rbrh5_0 bn5_0 bn5_1 5.9482
rbrv5_0 bn5_0 bn6_0 0.12867
rbrh5_1 bn5_1 bn5_2 0.27021
rbrv5_1 bn5_1 bn6_1 0.019452
rbrh5_2 bn5_2 bn5_3 0.078267
rbrv5_2 bn5_2 bn6_2 5.2072
rbrh5_3 bn5_3 bn5_4 0.010993
rbrv5_3 bn5_3 bn6_3 0.3659
rbrh5_4 bn5_4 bn5_5 1.8531
rbrv5_4 bn5_4 bn6_4 0.28307
rbrh5_5 bn5_5 bn5_6 0.012207
rbrv5_5 bn5_5 bn6_5 1.601
rbrh5_6 bn5_6 bn5_7 1.6014
rbrv5_6 bn5_6 bn6_6 0.38778
rbrh5_7 bn5_7 bn5_8 0.14101
rbrv5_7 bn5_7 bn6_7 0.025189
rbrh5_8 bn5_8 bn5_9 0.31118
rbrv5_8 bn5_8 bn6_8 0.11865
rbrh5_9 bn5_9 bn5_10 91.926
rbrv5_9 bn5_9 bn6_9 37.363
rbrh5_10 bn5_10 bn5_11 0.017907
rbrv5_10 bn5_10 bn6_10 50.476
rbrh5_11 bn5_11 bn5_12 0.048368
rbrv5_11 bn5_11 bn6_11 0.019765
rbrh5_12 bn5_12 bn5_13 0.063423
rbrv5_12 bn5_12 bn6_12 0.49729
rbrh5_13 bn5_13 bn5_14 31.728
rbrv5_13 bn5_13 bn6_13 0.36733
rbrh5_14 bn5_14 bn5_15 0.75078
rbrv5_14 bn5_14 bn6_14 5.9875
rbrh5_15 bn5_15 bn5_16 40.414
rbrv5_15 bn5_15 bn6_15 0.12894
rbrh5_16 bn5_16 bn5_17 0.011383
rbrv5_16 bn5_16 bn6_16 3.8191
rbrh5_17 bn5_17 bn5_18 0.043194
rbrv5_17 bn5_17 bn6_17 25.617
rbrh5_18 bn5_18 bn5_19 12.395
rbrv5_18 bn5_18 bn6_18 0.012598
rbrh5_19 bn5_19 bn5_20 0.44806
rbrv5_19 bn5_19 bn6_19 0.061961
rbrh5_20 bn5_20 bn5_21 68.951
rbrv5_20 bn5_20 bn6_20 85.972
rbrv5_21 bn5_21 bn6_21 2.8234
rbrh6_0 bn6_0 bn6_1 14.586
rbrv6_0 bn6_0 bn7_0 12.83
rbrh6_1 bn6_1 bn6_2 0.040898
rbrv6_1 bn6_1 bn7_1 26.512
rbrh6_2 bn6_2 bn6_3 19.629
rbrv6_2 bn6_2 bn7_2 2.5001
rbrh6_3 bn6_3 bn6_4 7.3621
rbrv6_3 bn6_3 bn7_3 0.042028
rbrh6_4 bn6_4 bn6_5 0.16336
rbrv6_4 bn6_4 bn7_4 2.3261
rbrh6_5 bn6_5 bn6_6 8.7872
rbrv6_5 bn6_5 bn7_5 1.2153
rbrh6_6 bn6_6 bn6_7 44.238
rbrv6_6 bn6_6 bn7_6 0.096877
rbrh6_7 bn6_7 bn6_8 0.32063
rbrv6_7 bn6_7 bn7_7 0.085631
rbrh6_8 bn6_8 bn6_9 3.604
rbrv6_8 bn6_8 bn7_8 0.01349
rbrh6_9 bn6_9 bn6_10 1.1105
rbrv6_9 bn6_9 bn7_9 50.037
rbrh6_10 bn6_10 bn6_11 3.4545
rbrv6_10 bn6_10 bn7_10 8.0998
rbrh6_11 bn6_11 bn6_12 0.047063
rbrv6_11 bn6_11 bn7_11 1.8334
rbrh6_12 bn6_12 bn6_13 1.4066
rbrv6_12 bn6_12 bn7_12 4.7506
rbrh6_13 bn6_13 bn6_14 22.016
rbrv6_13 bn6_13 bn7_13 2.1985
rbrh6_14 bn6_14 bn6_15 85.557
rbrv6_14 bn6_14 bn7_14 0.45874
rbrh6_15 bn6_15 bn6_16 0.018468
rbrv6_15 bn6_15 bn7_15 0.16103
rbrh6_16 bn6_16 bn6_17 1.2731
rbrv6_16 bn6_16 bn7_16 0.6574
rbrh6_17 bn6_17 bn6_18 26.855
rbrv6_17 bn6_17 bn7_17 0.121
rbrh6_18 bn6_18 bn6_19 0.19653
rbrv6_18 bn6_18 bn7_18 0.43759
rbrh6_19 bn6_19 bn6_20 0.20597
rbrv6_19 bn6_19 bn7_19 0.023812
rbrh6_20 bn6_20 bn6_21 0.10715
rbrv6_20 bn6_20 bn7_20 1.3
rbrv6_21 bn6_21 bn7_21 23.101
rbrh7_0 bn7_0 bn7_1 0.018708
rbrv7_0 bn7_0 bn8_0 0.097078
rbrh7_1 bn7_1 bn7_2 57.434
rbrv7_1 bn7_1 bn8_1 0.014227
rbrh7_2 bn7_2 bn7_3 88.777
rbrv7_2 bn7_2 bn8_2 35.224
rbrh7_3 bn7_3 bn7_4 0.097924
rbrv7_3 bn7_3 bn8_3 0.030583
rbrh7_4 bn7_4 bn7_5 0.048549
rbrv7_4 bn7_4 bn8_4 0.012701
rbrh7_5 bn7_5 bn7_6 0.012244
rbrv7_5 bn7_5 bn8_5 0.98937
rbrh7_6 bn7_6 bn7_7 0.010151
rbrv7_6 bn7_6 bn8_6 1.0946
rbrh7_7 bn7_7 bn7_8 33.567
rbrv7_7 bn7_7 bn8_7 1.1284
rbrh7_8 bn7_8 bn7_9 0.3389
rbrv7_8 bn7_8 bn8_8 18.839
rbrh7_9 bn7_9 bn7_10 0.23682
rbrv7_9 bn7_9 bn8_9 11.573
rbrh7_10 bn7_10 bn7_11 0.013642
rbrv7_10 bn7_10 bn8_10 0.019446
rbrh7_11 bn7_11 bn7_12 66.452
rbrv7_11 bn7_11 bn8_11 0.045887
rbrh7_12 bn7_12 bn7_13 9.1947
rbrv7_12 bn7_12 bn8_12 26.493
rbrh7_13 bn7_13 bn7_14 0.034554
rbrv7_13 bn7_13 bn8_13 41.919
rbrh7_14 bn7_14 bn7_15 5.2951
rbrv7_14 bn7_14 bn8_14 0.014956
rbrh7_15 bn7_15 bn7_16 0.17365
rbrv7_15 bn7_15 bn8_15 0.30346
rbrh7_16 bn7_16 bn7_17 0.049829
rbrv7_16 bn7_16 bn8_16 1.1352
rbrh7_17 bn7_17 bn7_18 55.118
rbrv7_17 bn7_17 bn8_17 0.62125
rbrh7_18 bn7_18 bn7_19 0.93914
rbrv7_18 bn7_18 bn8_18 0.28286
rbrh7_19 bn7_19 bn7_20 0.45716
rbrv7_19 bn7_19 bn8_19 0.012854
rbrh7_20 bn7_20 bn7_21 13.526
rbrv7_20 bn7_20 bn8_20 0.45196
rbrv7_21 bn7_21 bn8_21 1.6401
rbrh8_0 bn8_0 bn8_1 0.18978
rbrv8_0 bn8_0 bn9_0 28
rbrh8_1 bn8_1 bn8_2 0.019762
rbrv8_1 bn8_1 bn9_1 2.9465
rbrh8_2 bn8_2 bn8_3 0.019322
rbrv8_2 bn8_2 bn9_2 0.24656
rbrh8_3 bn8_3 bn8_4 0.081712
rbrv8_3 bn8_3 bn9_3 0.11402
rbrh8_4 bn8_4 bn8_5 0.16974
rbrv8_4 bn8_4 bn9_4 76.296
rbrh8_5 bn8_5 bn8_6 86.831
rbrv8_5 bn8_5 bn9_5 23.337
rbrh8_6 bn8_6 bn8_7 45.065
rbrv8_6 bn8_6 bn9_6 0.012011
rbrh8_7 bn8_7 bn8_8 30.255
rbrv8_7 bn8_7 bn9_7 0.026531
rbrh8_8 bn8_8 bn8_9 60.089
rbrv8_8 bn8_8 bn9_8 2.717
rbrh8_9 bn8_9 bn8_10 49.3
rbrv8_9 bn8_9 bn9_9 0.042969
rbrh8_10 bn8_10 bn8_11 5.8846
rbrv8_10 bn8_10 bn9_10 0.016633
rbrh8_11 bn8_11 bn8_12 10.579
rbrv8_11 bn8_11 bn9_11 0.027153
rbrh8_12 bn8_12 bn8_13 0.52587
rbrv8_12 bn8_12 bn9_12 5.0432
rbrh8_13 bn8_13 bn8_14 0.021393
rbrv8_13 bn8_13 bn9_13 0.15694
rbrh8_14 bn8_14 bn8_15 0.056522
rbrv8_14 bn8_14 bn9_14 0.057144
rbrh8_15 bn8_15 bn8_16 1.2492
rbrv8_15 bn8_15 bn9_15 0.021173
rbrh8_16 bn8_16 bn8_17 86.665
rbrv8_16 bn8_16 bn9_16 0.014018
rbrh8_17 bn8_17 bn8_18 0.53852
rbrv8_17 bn8_17 bn9_17 1.6931
rbrh8_18 bn8_18 bn8_19 0.015522
rbrv8_18 bn8_18 bn9_18 0.064091
rbrh8_19 bn8_19 bn8_20 47.913
rbrv8_19 bn8_19 bn9_19 12.003
rbrh8_20 bn8_20 bn8_21 69.14
rbrv8_20 bn8_20 bn9_20 0.019354
rbrv8_21 bn8_21 bn9_21 70.289
rbrh9_0 bn9_0 bn9_1 0.037657
rbrv9_0 bn9_0 bn10_0 0.011899
rbrh9_1 bn9_1 bn9_2 68.636
rbrv9_1 bn9_1 bn10_1 0.010146
rbrh9_2 bn9_2 bn9_3 36.579
rbrv9_2 bn9_2 bn10_2 0.087712
rbrh9_3 bn9_3 bn9_4 0.24812
rbrv9_3 bn9_3 bn10_3 4.0003
rbrh9_4 bn9_4 bn9_5 0.6411
rbrv9_4 bn9_4 bn10_4 0.24967
rbrh9_5 bn9_5 bn9_6 0.13597
rbrv9_5 bn9_5 bn10_5 0.30713
rbrh9_6 bn9_6 bn9_7 0.33231
rbrv9_6 bn9_6 bn10_6 12.937
rbrh9_7 bn9_7 bn9_8 0.02877
rbrv9_7 bn9_7 bn10_7 1.7902
rbrh9_8 bn9_8 bn9_9 0.037947
rbrv9_8 bn9_8 bn10_8 0.16194
rbrh9_9 bn9_9 bn9_10 0.48947
rbrv9_9 bn9_9 bn10_9 0.016513
rbrh9_10 bn9_10 bn9_11 0.025579
rbrv9_10 bn9_10 bn10_10 2.3882
rbrh9_11 bn9_11 bn9_12 62.779
rbrv9_11 bn9_11 bn10_11 0.092934
rbrh9_12 bn9_12 bn9_13 0.092593
rbrv9_12 bn9_12 bn10_12 2.1705
rbrh9_13 bn9_13 bn9_14 1.824
rbrv9_13 bn9_13 bn10_13 3.1857
rbrh9_14 bn9_14 bn9_15 2.2657
rbrv9_14 bn9_14 bn10_14 0.30124
rbrh9_15 bn9_15 bn9_16 33.562
rbrv9_15 bn9_15 bn10_15 5.3346
rbrh9_16 bn9_16 bn9_17 76.59
rbrv9_16 bn9_16 bn10_16 0.38294
rbrh9_17 bn9_17 bn9_18 10.855
rbrv9_17 bn9_17 bn10_17 0.049634
rbrh9_18 bn9_18 bn9_19 1.7504
rbrv9_18 bn9_18 bn10_18 0.068466
rbrh9_19 bn9_19 bn9_20 0.058177
rbrv9_19 bn9_19 bn10_19 2.9708
rbrh9_20 bn9_20 bn9_21 10.85
rbrv9_20 bn9_20 bn10_20 2.6414
rbrv9_21 bn9_21 bn10_21 10.029
rbrh10_0 bn10_0 bn10_1 89.715
rbrv10_0 bn10_0 bn11_0 1.2959
rbrh10_1 bn10_1 bn10_2 6.6347
rbrv10_1 bn10_1 bn11_1 12.851
rbrh10_2 bn10_2 bn10_3 11.756
rbrv10_2 bn10_2 bn11_2 9.6522
rbrh10_3 bn10_3 bn10_4 8.3217
rbrv10_3 bn10_3 bn11_3 0.028322
rbrh10_4 bn10_4 bn10_5 46.974
rbrv10_4 bn10_4 bn11_4 0.014447
rbrh10_5 bn10_5 bn10_6 6.8916
rbrv10_5 bn10_5 bn11_5 85.05
rbrh10_6 bn10_6 bn10_7 0.19606
rbrv10_6 bn10_6 bn11_6 0.01041
rbrh10_7 bn10_7 bn10_8 0.070847
rbrv10_7 bn10_7 bn11_7 0.04512
rbrh10_8 bn10_8 bn10_9 0.021327
rbrv10_8 bn10_8 bn11_8 4.9031
rbrh10_9 bn10_9 bn10_10 0.012852
rbrv10_9 bn10_9 bn11_9 0.13062
rbrh10_10 bn10_10 bn10_11 5.7498
rbrv10_10 bn10_10 bn11_10 0.013581
rbrh10_11 bn10_11 bn10_12 7.7532
rbrv10_11 bn10_11 bn11_11 76.953
rbrh10_12 bn10_12 bn10_13 8.1451
rbrv10_12 bn10_12 bn11_12 0.032028
rbrh10_13 bn10_13 bn10_14 0.081907
rbrv10_13 bn10_13 bn11_13 3.5273
rbrh10_14 bn10_14 bn10_15 0.75035
rbrv10_14 bn10_14 bn11_14 0.011616
rbrh10_15 bn10_15 bn10_16 3.5379
rbrv10_15 bn10_15 bn11_15 0.030288
rbrh10_16 bn10_16 bn10_17 0.18264
rbrv10_16 bn10_16 bn11_16 0.081921
rbrh10_17 bn10_17 bn10_18 40.984
rbrv10_17 bn10_17 bn11_17 73.659
rbrh10_18 bn10_18 bn10_19 0.36118
rbrv10_18 bn10_18 bn11_18 0.51524
rbrh10_19 bn10_19 bn10_20 0.4518
rbrv10_19 bn10_19 bn11_19 38.747
rbrh10_20 bn10_20 bn10_21 11.446
rbrv10_20 bn10_20 bn11_20 0.029769
rbrv10_21 bn10_21 bn11_21 0.21627
rbrh11_0 bn11_0 bn11_1 0.4376
rbrv11_0 bn11_0 bn12_0 32.465
rbrh11_1 bn11_1 bn11_2 0.64741
rbrv11_1 bn11_1 bn12_1 38.728
rbrh11_2 bn11_2 bn11_3 0.12581
rbrv11_2 bn11_2 bn12_2 35.427
rbrh11_3 bn11_3 bn11_4 0.93395
rbrv11_3 bn11_3 bn12_3 92.382
rbrh11_4 bn11_4 bn11_5 49.931
rbrv11_4 bn11_4 bn12_4 0.050761
rbrh11_5 bn11_5 bn11_6 0.094384
rbrv11_5 bn11_5 bn12_5 0.44967
rbrh11_6 bn11_6 bn11_7 2.6361
rbrv11_6 bn11_6 bn12_6 0.88625
rbrh11_7 bn11_7 bn11_8 3.78
rbrv11_7 bn11_7 bn12_7 0.72062
rbrh11_8 bn11_8 bn11_9 13.661
rbrv11_8 bn11_8 bn12_8 0.021202
rbrh11_9 bn11_9 bn11_10 0.19401
rbrv11_9 bn11_9 bn12_9 55.56
rbrh11_10 bn11_10 bn11_11 10.132
rbrv11_10 bn11_10 bn12_10 1.6738
rbrh11_11 bn11_11 bn11_12 22.573
rbrv11_11 bn11_11 bn12_11 27.079
rbrh11_12 bn11_12 bn11_13 2.0331
rbrv11_12 bn11_12 bn12_12 0.1529
rbrh11_13 bn11_13 bn11_14 0.1319
rbrv11_13 bn11_13 bn12_13 10.047
rbrh11_14 bn11_14 bn11_15 0.936
rbrv11_14 bn11_14 bn12_14 0.043377
rbrh11_15 bn11_15 bn11_16 7.8282
rbrv11_15 bn11_15 bn12_15 0.17466
rbrh11_16 bn11_16 bn11_17 5.1896
rbrv11_16 bn11_16 bn12_16 0.016062
rbrh11_17 bn11_17 bn11_18 3.4088
rbrv11_17 bn11_17 bn12_17 2.8552
rbrh11_18 bn11_18 bn11_19 0.033206
rbrv11_18 bn11_18 bn12_18 16.883
rbrh11_19 bn11_19 bn11_20 43.057
rbrv11_19 bn11_19 bn12_19 1.8508
rbrh11_20 bn11_20 bn11_21 2.3375
rbrv11_20 bn11_20 bn12_20 1.2772
rbrv11_21 bn11_21 bn12_21 0.018238
rbrh12_0 bn12_0 bn12_1 0.022209
rbrv12_0 bn12_0 bn13_0 0.17594
rbrh12_1 bn12_1 bn12_2 0.10643
rbrv12_1 bn12_1 bn13_1 0.21395
rbrh12_2 bn12_2 bn12_3 36.801
rbrv12_2 bn12_2 bn13_2 0.47588
rbrh12_3 bn12_3 bn12_4 0.025856
rbrv12_3 bn12_3 bn13_3 0.71022
rbrh12_4 bn12_4 bn12_5 2.2596
rbrv12_4 bn12_4 bn13_4 96.307
rbrh12_5 bn12_5 bn12_6 1.1732
rbrv12_5 bn12_5 bn13_5 65.869
rbrh12_6 bn12_6 bn12_7 14.797
rbrv12_6 bn12_6 bn13_6 0.012802
rbrh12_7 bn12_7 bn12_8 52.513
rbrv12_7 bn12_7 bn13_7 0.012495
rbrh12_8 bn12_8 bn12_9 32.679
rbrv12_8 bn12_8 bn13_8 0.018837
rbrh12_9 bn12_9 bn12_10 22.988
rbrv12_9 bn12_9 bn13_9 0.80923
rbrh12_10 bn12_10 bn12_11 0.78246
rbrv12_10 bn12_10 bn13_10 0.16827
rbrh12_11 bn12_11 bn12_12 19.646
rbrv12_11 bn12_11 bn13_11 0.013998
rbrh12_12 bn12_12 bn12_13 0.21072
rbrv12_12 bn12_12 bn13_12 0.74406
rbrh12_13 bn12_13 bn12_14 24.763
rbrv12_13 bn12_13 bn13_13 0.36897
rbrh12_14 bn12_14 bn12_15 0.16019
rbrv12_14 bn12_14 bn13_14 1.5729
rbrh12_15 bn12_15 bn12_16 0.081719
rbrv12_15 bn12_15 bn13_15 1.002
rbrh12_16 bn12_16 bn12_17 3.3612
rbrv12_16 bn12_16 bn13_16 0.040295
rbrh12_17 bn12_17 bn12_18 3.2454
rbrv12_17 bn12_17 bn13_17 76.096
rbrh12_18 bn12_18 bn12_19 8.5164
rbrv12_18 bn12_18 bn13_18 6.2662
rbrh12_19 bn12_19 bn12_20 1.1299
rbrv12_19 bn12_19 bn13_19 0.74627
rbrh12_20 bn12_20 bn12_21 57.7
rbrv12_20 bn12_20 bn13_20 3.7508
rbrv12_21 bn12_21 bn13_21 0.56683
rbrh13_0 bn13_0 bn13_1 60.786
rbrv13_0 bn13_0 bn14_0 0.034466
rbrh13_1 bn13_1 bn13_2 7.7366
rbrv13_1 bn13_1 bn14_1 5.733
rbrh13_2 bn13_2 bn13_3 3.7983
rbrv13_2 bn13_2 bn14_2 5.6392
rbrh13_3 bn13_3 bn13_4 28.539
rbrv13_3 bn13_3 bn14_3 1.1959
rbrh13_4 bn13_4 bn13_5 0.12794
rbrv13_4 bn13_4 bn14_4 0.18351
rbrh13_5 bn13_5 bn13_6 0.10368
rbrv13_5 bn13_5 bn14_5 2.6404
rbrh13_6 bn13_6 bn13_7 0.42065
rbrv13_6 bn13_6 bn14_6 32.205
rbrh13_7 bn13_7 bn13_8 0.014
rbrv13_7 bn13_7 bn14_7 0.056695
rbrh13_8 bn13_8 bn13_9 0.25379
rbrv13_8 bn13_8 bn14_8 0.15996
rbrh13_9 bn13_9 bn13_10 0.73884
rbrv13_9 bn13_9 bn14_9 2.5481
rbrh13_10 bn13_10 bn13_11 0.91974
rbrv13_10 bn13_10 bn14_10 0.62071
rbrh13_11 bn13_11 bn13_12 0.011752
rbrv13_11 bn13_11 bn14_11 0.010543
rbrh13_12 bn13_12 bn13_13 0.32596
rbrv13_12 bn13_12 bn14_12 80.324
rbrh13_13 bn13_13 bn13_14 0.35207
rbrv13_13 bn13_13 bn14_13 0.42935
rbrh13_14 bn13_14 bn13_15 0.053754
rbrv13_14 bn13_14 bn14_14 2.4196
rbrh13_15 bn13_15 bn13_16 0.037917
rbrv13_15 bn13_15 bn14_15 1.6089
rbrh13_16 bn13_16 bn13_17 0.55176
rbrv13_16 bn13_16 bn14_16 0.055745
rbrh13_17 bn13_17 bn13_18 0.095412
rbrv13_17 bn13_17 bn14_17 3.6819
rbrh13_18 bn13_18 bn13_19 0.33148
rbrv13_18 bn13_18 bn14_18 0.030714
rbrh13_19 bn13_19 bn13_20 44.442
rbrv13_19 bn13_19 bn14_19 88.966
rbrh13_20 bn13_20 bn13_21 26.064
rbrv13_20 bn13_20 bn14_20 3.1928
rbrv13_21 bn13_21 bn14_21 0.02761
rbrh14_0 bn14_0 bn14_1 0.28799
rbrv14_0 bn14_0 bn15_0 0.19308
rbrh14_1 bn14_1 bn14_2 2.6396
rbrv14_1 bn14_1 bn15_1 0.14575
rbrh14_2 bn14_2 bn14_3 0.29946
rbrv14_2 bn14_2 bn15_2 1.9543
rbrh14_3 bn14_3 bn14_4 0.09652
rbrv14_3 bn14_3 bn15_3 57.22
rbrh14_4 bn14_4 bn14_5 32.451
rbrv14_4 bn14_4 bn15_4 48.798
rbrh14_5 bn14_5 bn14_6 8.7874
rbrv14_5 bn14_5 bn15_5 0.01095
rbrh14_6 bn14_6 bn14_7 14.28
rbrv14_6 bn14_6 bn15_6 4.4055
rbrh14_7 bn14_7 bn14_8 37.396
rbrv14_7 bn14_7 bn15_7 6.531
rbrh14_8 bn14_8 bn14_9 18.645
rbrv14_8 bn14_8 bn15_8 62.476
rbrh14_9 bn14_9 bn14_10 6.9985
rbrv14_9 bn14_9 bn15_9 21.725
rbrh14_10 bn14_10 bn14_11 19.867
rbrv14_10 bn14_10 bn15_10 82.302
rbrh14_11 bn14_11 bn14_12 0.80469
rbrv14_11 bn14_11 bn15_11 39.431
rbrh14_12 bn14_12 bn14_13 0.13877
rbrv14_12 bn14_12 bn15_12 24.392
rbrh14_13 bn14_13 bn14_14 2.1861
rbrv14_13 bn14_13 bn15_13 1.4616
rbrh14_14 bn14_14 bn14_15 0.046352
rbrv14_14 bn14_14 bn15_14 2.0511
rbrh14_15 bn14_15 bn14_16 4.1102
rbrv14_15 bn14_15 bn15_15 1.79
rbrh14_16 bn14_16 bn14_17 29.144
rbrv14_16 bn14_16 bn15_16 0.3955
rbrh14_17 bn14_17 bn14_18 0.013147
rbrv14_17 bn14_17 bn15_17 0.19565
rbrh14_18 bn14_18 bn14_19 0.032432
rbrv14_18 bn14_18 bn15_18 8.2061
rbrh14_19 bn14_19 bn14_20 0.012133
rbrv14_19 bn14_19 bn15_19 6.893
rbrh14_20 bn14_20 bn14_21 3.5575
rbrv14_20 bn14_20 bn15_20 4.0947
rbrv14_21 bn14_21 bn15_21 0.66479
rbrh15_0 bn15_0 bn15_1 3.088
rbrv15_0 bn15_0 bn16_0 0.10379
rbrh15_1 bn15_1 bn15_2 0.041186
rbrv15_1 bn15_1 bn16_1 13.133
rbrh15_2 bn15_2 bn15_3 0.13033
rbrv15_2 bn15_2 bn16_2 0.49175
rbrh15_3 bn15_3 bn15_4 1.9923
rbrv15_3 bn15_3 bn16_3 0.018405
rbrh15_4 bn15_4 bn15_5 0.069036
rbrv15_4 bn15_4 bn16_4 0.34543
rbrh15_5 bn15_5 bn15_6 0.072768
rbrv15_5 bn15_5 bn16_5 5.9813
rbrh15_6 bn15_6 bn15_7 37.105
rbrv15_6 bn15_6 bn16_6 2.2721
rbrh15_7 bn15_7 bn15_8 83.341
rbrv15_7 bn15_7 bn16_7 0.022309
rbrh15_8 bn15_8 bn15_9 2.8302
rbrv15_8 bn15_8 bn16_8 2.1074
rbrh15_9 bn15_9 bn15_10 27.063
rbrv15_9 bn15_9 bn16_9 0.61585
rbrh15_10 bn15_10 bn15_11 0.96513
rbrv15_10 bn15_10 bn16_10 0.011365
rbrh15_11 bn15_11 bn15_12 6.392
rbrv15_11 bn15_11 bn16_11 16.312
rbrh15_12 bn15_12 bn15_13 1.1577
rbrv15_12 bn15_12 bn16_12 28.237
rbrh15_13 bn15_13 bn15_14 1.6716
rbrv15_13 bn15_13 bn16_13 46.113
rbrh15_14 bn15_14 bn15_15 0.018684
rbrv15_14 bn15_14 bn16_14 0.37943
rbrh15_15 bn15_15 bn15_16 11.504
rbrv15_15 bn15_15 bn16_15 0.51207
rbrh15_16 bn15_16 bn15_17 2.041
rbrv15_16 bn15_16 bn16_16 0.016679
rbrh15_17 bn15_17 bn15_18 0.12387
rbrv15_17 bn15_17 bn16_17 20.019
rbrh15_18 bn15_18 bn15_19 0.53111
rbrv15_18 bn15_18 bn16_18 0.11321
rbrh15_19 bn15_19 bn15_20 2.9985
rbrv15_19 bn15_19 bn16_19 0.18716
rbrh15_20 bn15_20 bn15_21 81.044
rbrv15_20 bn15_20 bn16_20 16.754
rbrv15_21 bn15_21 bn16_21 0.19383
rbrh16_0 bn16_0 bn16_1 0.14553
rbrv16_0 bn16_0 bn17_0 0.25127
rbrh16_1 bn16_1 bn16_2 2.126
rbrv16_1 bn16_1 bn17_1 0.26332
rbrh16_2 bn16_2 bn16_3 40.257
rbrv16_2 bn16_2 bn17_2 38.679
rbrh16_3 bn16_3 bn16_4 15.618
rbrv16_3 bn16_3 bn17_3 24.155
rbrh16_4 bn16_4 bn16_5 2.6809
rbrv16_4 bn16_4 bn17_4 0.7507
rbrh16_5 bn16_5 bn16_6 0.092602
rbrv16_5 bn16_5 bn17_5 0.57702
rbrh16_6 bn16_6 bn16_7 0.89986
rbrv16_6 bn16_6 bn17_6 4.4468
rbrh16_7 bn16_7 bn16_8 0.011547
rbrv16_7 bn16_7 bn17_7 65.22
rbrh16_8 bn16_8 bn16_9 0.56118
rbrv16_8 bn16_8 bn17_8 0.076466
rbrh16_9 bn16_9 bn16_10 0.26213
rbrv16_9 bn16_9 bn17_9 0.75643
rbrh16_10 bn16_10 bn16_11 0.020835
rbrv16_10 bn16_10 bn17_10 0.73866
rbrh16_11 bn16_11 bn16_12 0.015975
rbrv16_11 bn16_11 bn17_11 24.352
rbrh16_12 bn16_12 bn16_13 0.018113
rbrv16_12 bn16_12 bn17_12 0.13993
rbrh16_13 bn16_13 bn16_14 0.028306
rbrv16_13 bn16_13 bn17_13 0.022343
rbrh16_14 bn16_14 bn16_15 3.6791
rbrv16_14 bn16_14 bn17_14 0.1211
rbrh16_15 bn16_15 bn16_16 2.3388
rbrv16_15 bn16_15 bn17_15 25.679
rbrh16_16 bn16_16 bn16_17 0.02121
rbrv16_16 bn16_16 bn17_16 0.030382
rbrh16_17 bn16_17 bn16_18 1.5384
rbrv16_17 bn16_17 bn17_17 0.1474
rbrh16_18 bn16_18 bn16_19 0.76392
rbrv16_18 bn16_18 bn17_18 0.059424
rbrh16_19 bn16_19 bn16_20 25.688
rbrv16_19 bn16_19 bn17_19 0.92226
rbrh16_20 bn16_20 bn16_21 0.74295
rbrv16_20 bn16_20 bn17_20 3.086
rbrv16_21 bn16_21 bn17_21 0.19857
rbrh17_0 bn17_0 bn17_1 26.089
rbrv17_0 bn17_0 bn18_0 1.0646
rbrh17_1 bn17_1 bn17_2 30.062
rbrv17_1 bn17_1 bn18_1 0.96719
rbrh17_2 bn17_2 bn17_3 0.35974
rbrv17_2 bn17_2 bn18_2 0.17956
rbrh17_3 bn17_3 bn17_4 38.06
rbrv17_3 bn17_3 bn18_3 0.63562
rbrh17_4 bn17_4 bn17_5 72.881
rbrv17_4 bn17_4 bn18_4 0.040853
rbrh17_5 bn17_5 bn17_6 0.013455
rbrv17_5 bn17_5 bn18_5 0.063698
rbrh17_6 bn17_6 bn17_7 1.5303
rbrv17_6 bn17_6 bn18_6 69.104
rbrh17_7 bn17_7 bn17_8 88.285
rbrv17_7 bn17_7 bn18_7 0.29406
rbrh17_8 bn17_8 bn17_9 45.847
rbrv17_8 bn17_8 bn18_8 0.15453
rbrh17_9 bn17_9 bn17_10 79.987
rbrv17_9 bn17_9 bn18_9 0.26918
rbrh17_10 bn17_10 bn17_11 0.26713
rbrv17_10 bn17_10 bn18_10 0.031844
rbrh17_11 bn17_11 bn17_12 0.17586
rbrv17_11 bn17_11 bn18_11 0.18298
rbrh17_12 bn17_12 bn17_13 0.7229
rbrv17_12 bn17_12 bn18_12 3.6166
rbrh17_13 bn17_13 bn17_14 4.3613
rbrv17_13 bn17_13 bn18_13 0.31353
rbrh17_14 bn17_14 bn17_15 1.4887
rbrv17_14 bn17_14 bn18_14 8.0976
rbrh17_15 bn17_15 bn17_16 0.29057
rbrv17_15 bn17_15 bn18_15 1.1484
rbrh17_16 bn17_16 bn17_17 0.28407
rbrv17_16 bn17_16 bn18_16 0.030149
rbrh17_17 bn17_17 bn17_18 2.072
rbrv17_17 bn17_17 bn18_17 0.023885
rbrh17_18 bn17_18 bn17_19 84.05
rbrv17_18 bn17_18 bn18_18 0.01294
rbrh17_19 bn17_19 bn17_20 1.1397
rbrv17_19 bn17_19 bn18_19 1.3848
rbrh17_20 bn17_20 bn17_21 1.9116
rbrv17_20 bn17_20 bn18_20 2.016
rbrv17_21 bn17_21 bn18_21 0.029814
rbrh18_0 bn18_0 bn18_1 1.272
rbrv18_0 bn18_0 bn19_0 65.628
rbrh18_1 bn18_1 bn18_2 1.4798
rbrv18_1 bn18_1 bn19_1 44.141
rbrh18_2 bn18_2 bn18_3 0.40894
rbrv18_2 bn18_2 bn19_2 0.014347
rbrh18_3 bn18_3 bn18_4 0.061888
rbrv18_3 bn18_3 bn19_3 16.409
rbrh18_4 bn18_4 bn18_5 0.51091
rbrv18_4 bn18_4 bn19_4 0.27205
rbrh18_5 bn18_5 bn18_6 0.068644
rbrv18_5 bn18_5 bn19_5 1.6279
rbrh18_6 bn18_6 bn18_7 0.039196
rbrv18_6 bn18_6 bn19_6 0.029747
rbrh18_7 bn18_7 bn18_8 38.273
rbrv18_7 bn18_7 bn19_7 0.92358
rbrh18_8 bn18_8 bn18_9 49.525
rbrv18_8 bn18_8 bn19_8 1.4933
rbrh18_9 bn18_9 bn18_10 0.64314
rbrv18_9 bn18_9 bn19_9 0.11604
rbrh18_10 bn18_10 bn18_11 30.908
rbrv18_10 bn18_10 bn19_10 0.02018
rbrh18_11 bn18_11 bn18_12 2.2793
rbrv18_11 bn18_11 bn19_11 12.75
rbrh18_12 bn18_12 bn18_13 9.7473
rbrv18_12 bn18_12 bn19_12 0.62111
rbrh18_13 bn18_13 bn18_14 0.035547
rbrv18_13 bn18_13 bn19_13 0.016576
rbrh18_14 bn18_14 bn18_15 1.6198
rbrv18_14 bn18_14 bn19_14 0.047372
rbrh18_15 bn18_15 bn18_16 5.9411
rbrv18_15 bn18_15 bn19_15 0.28266
rbrh18_16 bn18_16 bn18_17 0.043261
rbrv18_16 bn18_16 bn19_16 23.663
rbrh18_17 bn18_17 bn18_18 7.7821
rbrv18_17 bn18_17 bn19_17 0.24854
rbrh18_18 bn18_18 bn18_19 0.35084
rbrv18_18 bn18_18 bn19_18 1.4105
rbrh18_19 bn18_19 bn18_20 0.7143
rbrv18_19 bn18_19 bn19_19 0.046045
rbrh18_20 bn18_20 bn18_21 0.016931
rbrv18_20 bn18_20 bn19_20 0.26183
rbrv18_21 bn18_21 bn19_21 0.34735
rbrh19_0 bn19_0 bn19_1 0.13413
rbrv19_0 bn19_0 bn20_0 39.031
rbrh19_1 bn19_1 bn19_2 62.609
rbrv19_1 bn19_1 bn20_1 0.568
rbrh19_2 bn19_2 bn19_3 0.85164
rbrv19_2 bn19_2 bn20_2 19.501
rbrh19_3 bn19_3 bn19_4 3.0974
rbrv19_3 bn19_3 bn20_3 46.255
rbrh19_4 bn19_4 bn19_5 2.0139
rbrv19_4 bn19_4 bn20_4 27.721
rbrh19_5 bn19_5 bn19_6 44.892
rbrv19_5 bn19_5 bn20_5 0.68149
rbrh19_6 bn19_6 bn19_7 0.022886
rbrv19_6 bn19_6 bn20_6 0.36386
rbrh19_7 bn19_7 bn19_8 0.22514
rbrv19_7 bn19_7 bn20_7 49.831
rbrh19_8 bn19_8 bn19_9 1.8627
rbrv19_8 bn19_8 bn20_8 0.65547
rbrh19_9 bn19_9 bn19_10 0.18912
rbrv19_9 bn19_9 bn20_9 0.84976
rbrh19_10 bn19_10 bn19_11 6.0006
rbrv19_10 bn19_10 bn20_10 28.601
rbrh19_11 bn19_11 bn19_12 4.5593
rbrv19_11 bn19_11 bn20_11 0.036837
rbrh19_12 bn19_12 bn19_13 0.30798
rbrv19_12 bn19_12 bn20_12 1.0266
rbrh19_13 bn19_13 bn19_14 0.028251
rbrv19_13 bn19_13 bn20_13 35.888
rbrh19_14 bn19_14 bn19_15 1.0322
rbrv19_14 bn19_14 bn20_14 14.578
rbrh19_15 bn19_15 bn19_16 10.072
rbrv19_15 bn19_15 bn20_15 12.278
rbrh19_16 bn19_16 bn19_17 0.040303
rbrv19_16 bn19_16 bn20_16 0.37718
rbrh19_17 bn19_17 bn19_18 0.29454
rbrv19_17 bn19_17 bn20_17 0.77113
rbrh19_18 bn19_18 bn19_19 0.019908
rbrv19_18 bn19_18 bn20_18 8.3733
rbrh19_19 bn19_19 bn19_20 0.1412
rbrv19_19 bn19_19 bn20_19 28.17
rbrh19_20 bn19_20 bn19_21 18.495
rbrv19_20 bn19_20 bn20_20 5.9805
rbrv19_21 bn19_21 bn20_21 87.024
rbrh20_0 bn20_0 bn20_1 0.039848
rbrv20_0 bn20_0 bn21_0 62.412
rbrh20_1 bn20_1 bn20_2 0.022554
rbrv20_1 bn20_1 bn21_1 0.05519
rbrh20_2 bn20_2 bn20_3 0.91308
rbrv20_2 bn20_2 bn21_2 0.12149
rbrh20_3 bn20_3 bn20_4 0.65365
rbrv20_3 bn20_3 bn21_3 0.062637
rbrh20_4 bn20_4 bn20_5 0.28101
rbrv20_4 bn20_4 bn21_4 0.014571
rbrh20_5 bn20_5 bn20_6 0.024432
rbrv20_5 bn20_5 bn21_5 6.5893
rbrh20_6 bn20_6 bn20_7 0.68363
rbrv20_6 bn20_6 bn21_6 10.852
rbrh20_7 bn20_7 bn20_8 2.7288
rbrv20_7 bn20_7 bn21_7 67.534
rbrh20_8 bn20_8 bn20_9 0.55671
rbrv20_8 bn20_8 bn21_8 2.036
rbrh20_9 bn20_9 bn20_10 0.0797
rbrv20_9 bn20_9 bn21_9 44.03
rbrh20_10 bn20_10 bn20_11 0.029079
rbrv20_10 bn20_10 bn21_10 51.95
rbrh20_11 bn20_11 bn20_12 0.013697
rbrv20_11 bn20_11 bn21_11 5.2514
rbrh20_12 bn20_12 bn20_13 5.1019
rbrv20_12 bn20_12 bn21_12 1.2833
rbrh20_13 bn20_13 bn20_14 3.8802
rbrv20_13 bn20_13 bn21_13 0.022293
rbrh20_14 bn20_14 bn20_15 7.8705
rbrv20_14 bn20_14 bn21_14 0.42301
rbrh20_15 bn20_15 bn20_16 8.7201
rbrv20_15 bn20_15 bn21_15 0.046761
rbrh20_16 bn20_16 bn20_17 50.796
rbrv20_16 bn20_16 bn21_16 0.42332
rbrh20_17 bn20_17 bn20_18 0.29557
rbrv20_17 bn20_17 bn21_17 3.6366
rbrh20_18 bn20_18 bn20_19 2.5958
rbrv20_18 bn20_18 bn21_18 22.279
rbrh20_19 bn20_19 bn20_20 0.046121
rbrv20_19 bn20_19 bn21_19 0.036349
rbrh20_20 bn20_20 bn20_21 5.7006
rbrv20_20 bn20_20 bn21_20 2.1644
rbrv20_21 bn20_21 bn21_21 0.14511
rbrh21_0 bn21_0 bn21_1 0.044466
rbrh21_1 bn21_1 bn21_2 0.011544
rbrh21_2 bn21_2 bn21_3 0.3283
rbrh21_3 bn21_3 bn21_4 0.010761
rbrh21_4 bn21_4 bn21_5 0.3853
rbrh21_5 bn21_5 bn21_6 2.0096
rbrh21_6 bn21_6 bn21_7 0.047863
rbrh21_7 bn21_7 bn21_8 6.4954
rbrh21_8 bn21_8 bn21_9 0.021558
rbrh21_9 bn21_9 bn21_10 3.3955
rbrh21_10 bn21_10 bn21_11 0.73929
rbrh21_11 bn21_11 bn21_12 0.010796
rbrh21_12 bn21_12 bn21_13 2.3408
rbrh21_13 bn21_13 bn21_14 6.763
rbrh21_14 bn21_14 bn21_15 0.28986
rbrh21_15 bn21_15 bn21_16 7.6391
rbrh21_16 bn21_16 bn21_17 56.591
rbrh21_17 bn21_17 bn21_18 26.955
rbrh21_18 bn21_18 bn21_19 43.674
rbrh21_19 bn21_19 bn21_20 0.05288
rbrh21_20 bn21_20 bn21_21 0.011858
rbp0 bp1 bn0_0 0.01
rbp1 bn0_21 0 0.01
rbp2 bn21_0 0 0.01
rbp3 bp2 bn21_21 0.01
vb1 bp1 0 DC 0
vb2 bp2 0 DC -0.7
ib3 0 bn11_7 DC 0
rcrh0_0 cn0_0 cn0_1 0.07949
rcrv0_0 cn0_0 cn1_0 0.043191
rcrh0_1 cn0_1 cn0_2 0.028901
rcrv0_1 cn0_1 cn1_1 0.77446
rcrh0_2 cn0_2 cn0_3 2.1612
rcrv0_2 cn0_2 cn1_2 0.05834
rcrh0_3 cn0_3 cn0_4 0.16298
rcrv0_3 cn0_3 cn1_3 21.178
rcrh0_4 cn0_4 cn0_5 5.4182
rcrv0_4 cn0_4 cn1_4 2.4593
rcrh0_5 cn0_5 cn0_6 0.46846
rcrv0_5 cn0_5 cn1_5 4.968
rcrh0_6 cn0_6 cn0_7 0.02753
rcrv0_6 cn0_6 cn1_6 0.13939
rcrh0_7 cn0_7 cn0_8 6.0318
rcrv0_7 cn0_7 cn1_7 60.963
rcrh0_8 cn0_8 cn0_9 0.21165
rcrv0_8 cn0_8 cn1_8 1.6668
rcrh0_9 cn0_9 cn0_10 0.010995
rcrv0_9 cn0_9 cn1_9 0.023165
rcrh0_10 cn0_10 cn0_11 16.849
rcrv0_10 cn0_10 cn1_10 10.344
rcrh0_11 cn0_11 cn0_12 2.5996
rcrv0_11 cn0_11 cn1_11 3.9229
rcrh0_12 cn0_12 cn0_13 0.011808
rcrv0_12 cn0_12 cn1_12 0.19891
rcrh0_13 cn0_13 cn0_14 34.492
rcrv0_13 cn0_13 cn1_13 13.64
rcrh0_14 cn0_14 cn0_15 0.024922
rcrv0_14 cn0_14 cn1_14 0.13267
rcrh0_15 cn0_15 cn0_16 0.40219
rcrv0_15 cn0_15 cn1_15 1.7994
rcrh0_16 cn0_16 cn0_17 0.26296
rcrv0_16 cn0_16 cn1_16 0.38977
rcrh0_17 cn0_17 cn0_18 1.202
rcrv0_17 cn0_17 cn1_17 0.30597
rcrh0_18 cn0_18 cn0_19 0.23269
rcrv0_18 cn0_18 cn1_18 0.031318
rcrh0_19 cn0_19 cn0_20 1.0647
rcrv0_19 cn0_19 cn1_19 6.0872
rcrh0_20 cn0_20 cn0_21 0.25332
rcrv0_20 cn0_20 cn1_20 3.5917
rcrv0_21 cn0_21 cn1_21 0.85048
rcrh1_0 cn1_0 cn1_1 0.6922
rcrv1_0 cn1_0 cn2_0 45.621
rcrh1_1 cn1_1 cn1_2 0.71431
rcrv1_1 cn1_1 cn2_1 0.13417
rcrh1_2 cn1_2 cn1_3 0.013207
rcrv1_2 cn1_2 cn2_2 0.54203
rcrh1_3 cn1_3 cn1_4 5.5036
rcrv1_3 cn1_3 cn2_3 5.0865
rcrh1_4 cn1_4 cn1_5 10.943
rcrv1_4 cn1_4 cn2_4 1.2935
rcrh1_5 cn1_5 cn1_6 34.522
rcrv1_5 cn1_5 cn2_5 0.13683
rcrh1_6 cn1_6 cn1_7 0.14296
rcrv1_6 cn1_6 cn2_6 0.020727
rcrh1_7 cn1_7 cn1_8 0.29661
rcrv1_7 cn1_7 cn2_7 69.16
rcrh1_8 cn1_8 cn1_9 0.013871
rcrv1_8 cn1_8 cn2_8 0.38808
rcrh1_9 cn1_9 cn1_10 0.72185
rcrv1_9 cn1_9 cn2_9 82.573
rcrh1_10 cn1_10 cn1_11 0.016368
rcrv1_10 cn1_10 cn2_10 34.725
rcrh1_11 cn1_11 cn1_12 15.726
rcrv1_11 cn1_11 cn2_11 40.729
rcrh1_12 cn1_12 cn1_13 0.1815
rcrv1_12 cn1_12 cn2_12 0.339
rcrh1_13 cn1_13 cn1_14 80.753
rcrv1_13 cn1_13 cn2_13 0.17824
rcrh1_14 cn1_14 cn1_15 0.015231
rcrv1_14 cn1_14 cn2_14 0.26242
rcrh1_15 cn1_15 cn1_16 2.1893
rcrv1_15 cn1_15 cn2_15 0.039898
rcrh1_16 cn1_16 cn1_17 65.903
rcrv1_16 cn1_16 cn2_16 6.0463
rcrh1_17 cn1_17 cn1_18 1.712
rcrv1_17 cn1_17 cn2_17 7.8001
rcrh1_18 cn1_18 cn1_19 0.41694
rcrv1_18 cn1_18 cn2_18 1.8557
rcrh1_19 cn1_19 cn1_20 0.12409
rcrv1_19 cn1_19 cn2_19 68.908
rcrh1_20 cn1_20 cn1_21 0.40098
rcrv1_20 cn1_20 cn2_20 0.015704
rcrv1_21 cn1_21 cn2_21 2.9761
rcrh2_0 cn2_0 cn2_1 4.1782
rcrv2_0 cn2_0 cn3_0 32.687
rcrh2_1 cn2_1 cn2_2 10.885
rcrv2_1 cn2_1 cn3_1 92.17
rcrh2_2 cn2_2 cn2_3 0.5774
rcrv2_2 cn2_2 cn3_2 14.271
rcrh2_3 cn2_3 cn2_4 0.025447
rcrv2_3 cn2_3 cn3_3 0.011217
rcrh2_4 cn2_4 cn2_5 57.129
rcrv2_4 cn2_4 cn3_4 5.6204
rcrh2_5 cn2_5 cn2_6 12.873
rcrv2_5 cn2_5 cn3_5 66.15
rcrh2_6 cn2_6 cn2_7 4.167
rcrv2_6 cn2_6 cn3_6 29.546
rcrh2_7 cn2_7 cn2_8 11.991
rcrv2_7 cn2_7 cn3_7 0.84034
rcrh2_8 cn2_8 cn2_9 1.5378
rcrv2_8 cn2_8 cn3_8 0.77671
rcrh2_9 cn2_9 cn2_10 0.97199
rcrv2_9 cn2_9 cn3_9 0.031234
rcrh2_10 cn2_10 cn2_11 48.476
rcrv2_10 cn2_10 cn3_10 1.6643
rcrh2_11 cn2_11 cn2_12 7.9116
rcrv2_11 cn2_11 cn3_11 0.40806
rcrh2_12 cn2_12 cn2_13 0.04472
rcrv2_12 cn2_12 cn3_12 4.545
rcrh2_13 cn2_13 cn2_14 0.034361
rcrv2_13 cn2_13 cn3_13 36.836
rcrh2_14 cn2_14 cn2_15 26.16
rcrv2_14 cn2_14 cn3_14 0.20188
rcrh2_15 cn2_15 cn2_16 0.62895
rcrv2_15 cn2_15 cn3_15 2.3787
rcrh2_16 cn2_16 cn2_17 0.012442
rcrv2_16 cn2_16 cn3_16 0.019225
rcrh2_17 cn2_17 cn2_18 18.08
rcrv2_17 cn2_17 cn3_17 6.437
rcrh2_18 cn2_18 cn2_19 0.018971
rcrv2_18 cn2_18 cn3_18 0.24233
rcrh2_19 cn2_19 cn2_20 7.7019
rcrv2_19 cn2_19 cn3_19 0.17618
rcrh2_20 cn2_20 cn2_21 0.015317
rcrv2_20 cn2_20 cn3_20 1.8787
rcrv2_21 cn2_21 cn3_21 19.61
rcrh3_0 cn3_0 cn3_1 1.0689
rcrv3_0 cn3_0 cn4_0 0.2415
rcrh3_1 cn3_1 cn3_2 0.46929
rcrv3_1 cn3_1 cn4_1 0.89046
rcrh3_2 cn3_2 cn3_3 13.198
rcrv3_2 cn3_2 cn4_2 4.9925
rcrh3_3 cn3_3 cn3_4 23
rcrv3_3 cn3_3 cn4_3 0.25447
rcrh3_4 cn3_4 cn3_5 0.019077
rcrv3_4 cn3_4 cn4_4 0.040085
rcrh3_5 cn3_5 cn3_6 9.1707
rcrv3_5 cn3_5 cn4_5 36.957
rcrh3_6 cn3_6 cn3_7 36.669
rcrv3_6 cn3_6 cn4_6 3.7385
rcrh3_7 cn3_7 cn3_8 0.13621
rcrv3_7 cn3_7 cn4_7 0.37056
rcrh3_8 cn3_8 cn3_9 2.2891
rcrv3_8 cn3_8 cn4_8 35.826
rcrh3_9 cn3_9 cn3_10 63.361
rcrv3_9 cn3_9 cn4_9 38.612
rcrh3_10 cn3_10 cn3_11 29.633
rcrv3_10 cn3_10 cn4_10 0.67233
rcrh3_11 cn3_11 cn3_12 4.1311
rcrv3_11 cn3_11 cn4_11 1.4558
rcrh3_12 cn3_12 cn3_13 9.9609
rcrv3_12 cn3_12 cn4_12 1.6093
rcrh3_13 cn3_13 cn3_14 0.67203
rcrv3_13 cn3_13 cn4_13 6.2123
rcrh3_14 cn3_14 cn3_15 40.961
rcrv3_14 cn3_14 cn4_14 9.9189
rcrh3_15 cn3_15 cn3_16 0.022801
rcrv3_15 cn3_15 cn4_15 7.8165
rcrh3_16 cn3_16 cn3_17 0.20934
rcrv3_16 cn3_16 cn4_16 0.36185
rcrh3_17 cn3_17 cn3_18 0.030169
rcrv3_17 cn3_17 cn4_17 0.39251
rcrh3_18 cn3_18 cn3_19 0.02581
rcrv3_18 cn3_18 cn4_18 3.5432
rcrh3_19 cn3_19 cn3_20 5.7127
rcrv3_19 cn3_19 cn4_19 24.462
rcrh3_20 cn3_20 cn3_21 0.47624
rcrv3_20 cn3_20 cn4_20 1.2544
rcrv3_21 cn3_21 cn4_21 0.015166
rcrh4_0 cn4_0 cn4_1 15.202
rcrv4_0 cn4_0 cn5_0 1.0369
rcrh4_1 cn4_1 cn4_2 68.81
rcrv4_1 cn4_1 cn5_1 3.4048
rcrh4_2 cn4_2 cn4_3 15.495
rcrv4_2 cn4_2 cn5_2 0.6625
rcrh4_3 cn4_3 cn4_4 0.35928
rcrv4_3 cn4_3 cn5_3 0.20089
rcrh4_4 cn4_4 cn4_5 38.517
rcrv4_4 cn4_4 cn5_4 41.402
rcrh4_5 cn4_5 cn4_6 0.010792
rcrv4_5 cn4_5 cn5_5 3.86
rcrh4_6 cn4_6 cn4_7 0.63189
rcrv4_6 cn4_6 cn5_6 35.075
rcrh4_7 cn4_7 cn4_8 25.152
rcrv4_7 cn4_7 cn5_7 0.41562
rcrh4_8 cn4_8 cn4_9 31.334
rcrv4_8 cn4_8 cn5_8 0.075579
rcrh4_9 cn4_9 cn4_10 76
rcrv4_9 cn4_9 cn5_9 0.32575
rcrh4_10 cn4_10 cn4_11 2.6932
rcrv4_10 cn4_10 cn5_10 54.979
rcrh4_11 cn4_11 cn4_12 0.36634
rcrv4_11 cn4_11 cn5_11 55.475
rcrh4_12 cn4_12 cn4_13 5.7295
rcrv4_12 cn4_12 cn5_12 0.13068
rcrh4_13 cn4_13 cn4_14 8.8078
rcrv4_13 cn4_13 cn5_13 0.65371
rcrh4_14 cn4_14 cn4_15 0.015192
rcrv4_14 cn4_14 cn5_14 0.015676
rcrh4_15 cn4_15 cn4_16 0.013824
rcrv4_15 cn4_15 cn5_15 5.5302
rcrh4_16 cn4_16 cn4_17 0.073462
rcrv4_16 cn4_16 cn5_16 0.1036
rcrh4_17 cn4_17 cn4_18 0.45409
rcrv4_17 cn4_17 cn5_17 0.074468
rcrh4_18 cn4_18 cn4_19 0.18253
rcrv4_18 cn4_18 cn5_18 0.247
rcrh4_19 cn4_19 cn4_20 0.12481
rcrv4_19 cn4_19 cn5_19 10.966
rcrh4_20 cn4_20 cn4_21 0.072396
rcrv4_20 cn4_20 cn5_20 72.642
rcrv4_21 cn4_21 cn5_21 0.10097
rcrh5_0 cn5_0 cn5_1 5.9482
rcrv5_0 cn5_0 cn6_0 0.12867
rcrh5_1 cn5_1 cn5_2 0.27021
rcrv5_1 cn5_1 cn6_1 0.019452
rcrh5_2 cn5_2 cn5_3 0.078267
rcrv5_2 cn5_2 cn6_2 5.2072
rcrh5_3 cn5_3 cn5_4 0.010993
rcrv5_3 cn5_3 cn6_3 0.3659
rcrh5_4 cn5_4 cn5_5 1.8531
rcrv5_4 cn5_4 cn6_4 0.28307
rcrh5_5 cn5_5 cn5_6 0.012207
rcrv5_5 cn5_5 cn6_5 1.601
rcrh5_6 cn5_6 cn5_7 1.6014
rcrv5_6 cn5_6 cn6_6 0.38778
rcrh5_7 cn5_7 cn5_8 0.14101
rcrv5_7 cn5_7 cn6_7 0.025189
rcrh5_8 cn5_8 cn5_9 0.31118
rcrv5_8 cn5_8 cn6_8 0.11865
rcrh5_9 cn5_9 cn5_10 91.926
rcrv5_9 cn5_9 cn6_9 37.363
rcrh5_10 cn5_10 cn5_11 0.017907
rcrv5_10 cn5_10 cn6_10 50.476
rcrh5_11 cn5_11 cn5_12 0.048368
rcrv5_11 cn5_11 cn6_11 0.019765
rcrh5_12 cn5_12 cn5_13 0.063423
rcrv5_12 cn5_12 cn6_12 0.49729
rcrh5_13 cn5_13 cn5_14 31.728
rcrv5_13 cn5_13 cn6_13 0.36733
rcrh5_14 cn5_14 cn5_15 0.75078
rcrv5_14 cn5_14 cn6_14 5.9875
rcrh5_15 cn5_15 cn5_16 40.414
rcrv5_15 cn5_15 cn6_15 0.12894
rcrh5_16 cn5_16 cn5_17 0.011383
rcrv5_16 cn5_16 cn6_16 3.8191
rcrh5_17 cn5_17 cn5_18 0.043194
rcrv5_17 cn5_17 cn6_17 25.617
rcrh5_18 cn5_18 cn5_19 12.395
rcrv5_18 cn5_18 cn6_18 0.012598
rcrh5_19 cn5_19 cn5_20 0.44806
rcrv5_19 cn5_19 cn6_19 0.061961
rcrh5_20 cn5_20 cn5_21 68.951
rcrv5_20 cn5_20 cn6_20 85.972
rcrv5_21 cn5_21 cn6_21 2.8234
rcrh6_0 cn6_0 cn6_1 14.586
rcrv6_0 cn6_0 cn7_0 12.83
rcrh6_1 cn6_1 cn6_2 0.040898
rcrv6_1 cn6_1 cn7_1 26.512
rcrh6_2 cn6_2 cn6_3 19.629
rcrv6_2 cn6_2 cn7_2 2.5001
rcrh6_3 cn6_3 cn6_4 7.3621
rcrv6_3 cn6_3 cn7_3 0.042028
rcrh6_4 cn6_4 cn6_5 0.16336
rcrv6_4 cn6_4 cn7_4 2.3261
rcrh6_5 cn6_5 cn6_6 8.7872
rcrv6_5 cn6_5 cn7_5 1.2153
rcrh6_6 cn6_6 cn6_7 44.238
rcrv6_6 cn6_6 cn7_6 0.096877
rcrh6_7 cn6_7 cn6_8 0.32063
rcrv6_7 cn6_7 cn7_7 0.085631
rcrh6_8 cn6_8 cn6_9 3.604
rcrv6_8 cn6_8 cn7_8 0.01349
rcrh6_9 cn6_9 cn6_10 1.1105
rcrv6_9 cn6_9 cn7_9 50.037
rcrh6_10 cn6_10 cn6_11 3.4545
rcrv6_10 cn6_10 cn7_10 8.0998
rcrh6_11 cn6_11 cn6_12 0.047063
rcrv6_11 cn6_11 cn7_11 1.8334
rcrh6_12 cn6_12 cn6_13 1.4066
rcrv6_12 cn6_12 cn7_12 4.7506
rcrh6_13 cn6_13 cn6_14 22.016
rcrv6_13 cn6_13 cn7_13 2.1985
rcrh6_14 cn6_14 cn6_15 85.557
rcrv6_14 cn6_14 cn7_14 0.45874
rcrh6_15 cn6_15 cn6_16 0.018468
rcrv6_15 cn6_15 cn7_15 0.16103
rcrh6_16 cn6_16 cn6_17 1.2731
rcrv6_16 cn6_16 cn7_16 0.6574
rcrh6_17 cn6_17 cn6_18 26.855
rcrv6_17 cn6_17 cn7_17 0.121
rcrh6_18 cn6_18 cn6_19 0.19653
rcrv6_18 cn6_18 cn7_18 0.43759
rcrh6_19 cn6_19 cn6_20 0.20597
rcrv6_19 cn6_19 cn7_19 0.023812
rcrh6_20 cn6_20 cn6_21 0.10715
rcrv6_20 cn6_20 cn7_20 1.3
rcrv6_21 cn6_21 cn7_21 23.101
rcrh7_0 cn7_0 cn7_1 0.018708
rcrv7_0 cn7_0 cn8_0 0.097078
rcrh7_1 cn7_1 cn7_2 57.434
rcrv7_1 cn7_1 cn8_1 0.014227
rcrh7_2 cn7_2 cn7_3 88.777
rcrv7_2 cn7_2 cn8_2 35.224
rcrh7_3 cn7_3 cn7_4 0.097924
rcrv7_3 cn7_3 cn8_3 0.030583
rcrh7_4 cn7_4 cn7_5 0.048549
rcrv7_4 cn7_4 cn8_4 0.012701
rcrh7_5 cn7_5 cn7_6 0.012244
rcrv7_5 cn7_5 cn8_5 0.98937
rcrh7_6 cn7_6 cn7_7 0.010151
rcrv7_6 cn7_6 cn8_6 1.0946
rcrh7_7 cn7_7 cn7_8 33.567
rcrv7_7 cn7_7 cn8_7 1.1284
rcrh7_8 cn7_8 cn7_9 0.3389
rcrv7_8 cn7_8 cn8_8 18.839
rcrh7_9 cn7_9 cn7_10 0.23682
rcrv7_9 cn7_9 cn8_9 11.573
rcrh7_10 cn7_10 cn7_11 0.013642
rcrv7_10 cn7_10 cn8_10 0.019446
rcrh7_11 cn7_11 cn7_12 66.452
rcrv7_11 cn7_11 cn8_11 0.045887
rcrh7_12 cn7_12 cn7_13 9.1947
rcrv7_12 cn7_12 cn8_12 26.493
rcrh7_13 cn7_13 cn7_14 0.034554
rcrv7_13 cn7_13 cn8_13 41.919
rcrh7_14 cn7_14 cn7_15 5.2951
rcrv7_14 cn7_14 cn8_14 0.014956
rcrh7_15 cn7_15 cn7_16 0.17365
rcrv7_15 cn7_15 cn8_15 0.30346
rcrh7_16 cn7_16 cn7_17 0.049829
rcrv7_16 cn7_16 cn8_16 1.1352
rcrh7_17 cn7_17 cn7_18 55.118
rcrv7_17 cn7_17 cn8_17 0.62125
rcrh7_18 cn7_18 cn7_19 0.93914
rcrv7_18 cn7_18 cn8_18 0.28286
rcrh7_19 cn7_19 cn7_20 0.45716
rcrv7_19 cn7_19 cn8_19 0.012854
rcrh7_20 cn7_20 cn7_21 13.526
rcrv7_20 cn7_20 cn8_20 0.45196
rcrv7_21 cn7_21 cn8_21 1.6401
rcrh8_0 cn8_0 cn8_1 0.18978
rcrv8_0 cn8_0 cn9_0 28
rcrh8_1 cn8_1 cn8_2 0.019762
rcrv8_1 cn8_1 cn9_1 2.9465
rcrh8_2 cn8_2 cn8_3 0.019322
rcrv8_2 cn8_2 cn9_2 0.24656
rcrh8_3 cn8_3 cn8_4 0.081712
rcrv8_3 cn8_3 cn9_3 0.11402
rcrh8_4 cn8_4 cn8_5 0.16974
rcrv8_4 cn8_4 cn9_4 76.296
rcrh8_5 cn8_5 cn8_6 86.831
rcrv8_5 cn8_5 cn9_5 23.337
rcrh8_6 cn8_6 cn8_7 45.065
rcrv8_6 cn8_6 cn9_6 0.012011
rcrh8_7 cn8_7 cn8_8 30.255
rcrv8_7 cn8_7 cn9_7 0.026531
rcrh8_8 cn8_8 cn8_9 60.089
rcrv8_8 cn8_8 cn9_8 2.717
rcrh8_9 cn8_9 cn8_10 49.3
rcrv8_9 cn8_9 cn9_9 0.042969
rcrh8_10 cn8_10 cn8_11 5.8846
rcrv8_10 cn8_10 cn9_10 0.016633
rcrh8_11 cn8_11 cn8_12 10.579
rcrv8_11 cn8_11 cn9_11 0.027153
rcrh8_12 cn8_12 cn8_13 0.52587
rcrv8_12 cn8_12 cn9_12 5.0432
rcrh8_13 cn8_13 cn8_14 0.021393
rcrv8_13 cn8_13 cn9_13 0.15694
rcrh8_14 cn8_14 cn8_15 0.056522
rcrv8_14 cn8_14 cn9_14 0.057144
rcrh8_15 cn8_15 cn8_16 1.2492
rcrv8_15 cn8_15 cn9_15 0.021173
rcrh8_16 cn8_16 cn8_17 86.665
rcrv8_16 cn8_16 cn9_16 0.014018
rcrh8_17 cn8_17 cn8_18 0.53852
rcrv8_17 cn8_17 cn9_17 1.6931
rcrh8_18 cn8_18 cn8_19 0.015522
rcrv8_18 cn8_18 cn9_18 0.064091
rcrh8_19 cn8_19 cn8_20 47.913
rcrv8_19 cn8_19 cn9_19 12.003
rcrh8_20 cn8_20 cn8_21 69.14
rcrv8_20 cn8_20 cn9_20 0.019354
rcrv8_21 cn8_21 cn9_21 70.289
rcrh9_0 cn9_0 cn9_1 0.037657
rcrv9_0 cn9_0 cn10_0 0.011899
rcrh9_1 cn9_1 cn9_2 68.636
rcrv9_1 cn9_1 cn10_1 0.010146
rcrh9_2 cn9_2 cn9_3 36.579
rcrv9_2 cn9_2 cn10_2 0.087712
rcrh9_3 cn9_3 cn9_4 0.24812
rcrv9_3 cn9_3 cn10_3 4.0003
rcrh9_4 cn9_4 cn9_5 0.6411
rcrv9_4 cn9_4 cn10_4 0.24967
rcrh9_5 cn9_5 cn9_6 0.13597
rcrv9_5 cn9_5 cn10_5 0.30713
rcrh9_6 cn9_6 cn9_7 0.33231
rcrv9_6 cn9_6 cn10_6 12.937
rcrh9_7 cn9_7 cn9_8 0.02877
rcrv9_7 cn9_7 cn10_7 1.7902
rcrh9_8 cn9_8 cn9_9 0.037947
rcrv9_8 cn9_8 cn10_8 0.16194
rcrh9_9 cn9_9 cn9_10 0.48947
rcrv9_9 cn9_9 cn10_9 0.016513
rcrh9_10 cn9_10 cn9_11 0.025579
rcrv9_10 cn9_10 cn10_10 2.3882
rcrh9_11 cn9_11 cn9_12 62.779
rcrv9_11 cn9_11 cn10_11 0.092934
rcrh9_12 cn9_12 cn9_13 0.092593
rcrv9_12 cn9_12 cn10_12 2.1705
rcrh9_13 cn9_13 cn9_14 1.824
rcrv9_13 cn9_13 cn10_13 3.1857
rcrh9_14 cn9_14 cn9_15 2.2657
rcrv9_14 cn9_14 cn10_14 0.30124
rcrh9_15 cn9_15 cn9_16 33.562
rcrv9_15 cn9_15 cn10_15 5.3346
rcrh9_16 cn9_16 cn9_17 76.59
rcrv9_16 cn9_16 cn10_16 0.38294
rcrh9_17 cn9_17 cn9_18 10.855
rcrv9_17 cn9_17 cn10_17 0.049634
rcrh9_18 cn9_18 cn9_19 1.7504
rcrv9_18 cn9_18 cn10_18 0.068466
rcrh9_19 cn9_19 cn9_20 0.058177
rcrv9_19 cn9_19 cn10_19 2.9708
rcrh9_20 cn9_20 cn9_21 10.85
rcrv9_20 cn9_20 cn10_20 2.6414
rcrv9_21 cn9_21 cn10_21 10.029
rcrh10_0 cn10_0 cn10_1 89.715
rcrv10_0 cn10_0 cn11_0 1.2959
rcrh10_1 cn10_1 cn10_2 6.6347
rcrv10_1 cn10_1 cn11_1 12.851
rcrh10_2 cn10_2 cn10_3 11.756
rcrv10_2 cn10_2 cn11_2 9.6522
rcrh10_3 cn10_3 cn10_4 8.3217
rcrv10_3 cn10_3 cn11_3 0.028322
rcrh10_4 cn10_4 cn10_5 46.974
rcrv10_4 cn10_4 cn11_4 0.014447
rcrh10_5 cn10_5 cn10_6 6.8916
rcrv10_5 cn10_5 cn11_5 85.05
rcrh10_6 cn10_6 cn10_7 0.19606
rcrv10_6 cn10_6 cn11_6 0.01041
rcrh10_7 cn10_7 cn10_8 0.070847
rcrv10_7 cn10_7 cn11_7 0.04512
rcrh10_8 cn10_8 cn10_9 0.021327
rcrv10_8 cn10_8 cn11_8 4.9031
rcrh10_9 cn10_9 cn10_10 0.012852
rcrv10_9 cn10_9 cn11_9 0.13062
rcrh10_10 cn10_10 cn10_11 5.7498
rcrv10_10 cn10_10 cn11_10 0.013581
rcrh10_11 cn10_11 cn10_12 7.7532
rcrv10_11 cn10_11 cn11_11 76.953
rcrh10_12 cn10_12 cn10_13 8.1451
rcrv10_12 cn10_12 cn11_12 0.032028
rcrh10_13 cn10_13 cn10_14 0.081907
rcrv10_13 cn10_13 cn11_13 3.5273
rcrh10_14 cn10_14 cn10_15 0.75035
rcrv10_14 cn10_14 cn11_14 0.011616
rcrh10_15 cn10_15 cn10_16 3.5379
rcrv10_15 cn10_15 cn11_15 0.030288
rcrh10_16 cn10_16 cn10_17 0.18264
rcrv10_16 cn10_16 cn11_16 0.081921
rcrh10_17 cn10_17 cn10_18 40.984
rcrv10_17 cn10_17 cn11_17 73.659
rcrh10_18 cn10_18 cn10_19 0.36118
rcrv10_18 cn10_18 cn11_18 0.51524
rcrh10_19 cn10_19 cn10_20 0.4518
rcrv10_19 cn10_19 cn11_19 38.747
rcrh10_20 cn10_20 cn10_21 11.446
rcrv10_20 cn10_20 cn11_20 0.029769
rcrv10_21 cn10_21 cn11_21 0.21627
rcrh11_0 cn11_0 cn11_1 0.4376
rcrv11_0 cn11_0 cn12_0 32.465
rcrh11_1 cn11_1 cn11_2 0.64741
rcrv11_1 cn11_1 cn12_1 38.728
rcrh11_2 cn11_2 cn11_3 0.12581
rcrv11_2 cn11_2 cn12_2 35.427
rcrh11_3 cn11_3 cn11_4 0.93395
rcrv11_3 cn11_3 cn12_3 92.382
rcrh11_4 cn11_4 cn11_5 49.931
rcrv11_4 cn11_4 cn12_4 0.050761
rcrh11_5 cn11_5 cn11_6 0.094384
rcrv11_5 cn11_5 cn12_5 0.44967
rcrh11_6 cn11_6 cn11_7 2.6361
rcrv11_6 cn11_6 cn12_6 0.88625
rcrh11_7 cn11_7 cn11_8 3.78
rcrv11_7 cn11_7 cn12_7 0.72062
rcrh11_8 cn11_8 cn11_9 13.661
rcrv11_8 cn11_8 cn12_8 0.021202
rcrh11_9 cn11_9 cn11_10 0.19401
rcrv11_9 cn11_9 cn12_9 55.56
rcrh11_10 cn11_10 cn11_11 10.132
rcrv11_10 cn11_10 cn12_10 1.6738
rcrh11_11 cn11_11 cn11_12 22.573
rcrv11_11 cn11_11 cn12_11 27.079
rcrh11_12 cn11_12 cn11_13 2.0331
rcrv11_12 cn11_12 cn12_12 0.1529
rcrh11_13 cn11_13 cn11_14 0.1319
rcrv11_13 cn11_13 cn12_13 10.047
rcrh11_14 cn11_14 cn11_15 0.936
rcrv11_14 cn11_14 cn12_14 0.043377
rcrh11_15 cn11_15 cn11_16 7.8282
rcrv11_15 cn11_15 cn12_15 0.17466
rcrh11_16 cn11_16 cn11_17 5.1896
rcrv11_16 cn11_16 cn12_16 0.016062
rcrh11_17 cn11_17 cn11_18 3.4088
rcrv11_17 cn11_17 cn12_17 2.8552
rcrh11_18 cn11_18 cn11_19 0.033206
rcrv11_18 cn11_18 cn12_18 16.883
rcrh11_19 cn11_19 cn11_20 43.057
rcrv11_19 cn11_19 cn12_19 1.8508
rcrh11_20 cn11_20 cn11_21 2.3375
rcrv11_20 cn11_20 cn12_20 1.2772
rcrv11_21 cn11_21 cn12_21 0.018238
rcrh12_0 cn12_0 cn12_1 0.022209
rcrv12_0 cn12_0 cn13_0 0.17594
rcrh12_1 cn12_1 cn12_2 0.10643
rcrv12_1 cn12_1 cn13_1 0.21395
rcrh12_2 cn12_2 cn12_3 36.801
rcrv12_2 cn12_2 cn13_2 0.47588
rcrh12_3 cn12_3 cn12_4 0.025856
rcrv12_3 cn12_3 cn13_3 0.71022
rcrh12_4 cn12_4 cn12_5 2.2596
rcrv12_4 cn12_4 cn13_4 96.307
rcrh12_5 cn12_5 cn12_6 1.1732
rcrv12_5 cn12_5 cn13_5 65.869
rcrh12_6 cn12_6 cn12_7 14.797
rcrv12_6 cn12_6 cn13_6 0.012802
rcrh12_7 cn12_7 cn12_8 52.513
rcrv12_7 cn12_7 cn13_7 0.012495
rcrh12_8 cn12_8 cn12_9 32.679
rcrv12_8 cn12_8 cn13_8 0.018837
rcrh12_9 cn12_9 cn12_10 22.988
rcrv12_9 cn12_9 cn13_9 0.80923
rcrh12_10 cn12_10 cn12_11 0.78246
rcrv12_10 cn12_10 cn13_10 0.16827
rcrh12_11 cn12_11 cn12_12 19.646
rcrv12_11 cn12_11 cn13_11 0.013998
rcrh12_12 cn12_12 cn12_13 0.21072
rcrv12_12 cn12_12 cn13_12 0.74406
rcrh12_13 cn12_13 cn12_14 24.763
rcrv12_13 cn12_13 cn13_13 0.36897
rcrh12_14 cn12_14 cn12_15 0.16019
rcrv12_14 cn12_14 cn13_14 1.5729
rcrh12_15 cn12_15 cn12_16 0.081719
rcrv12_15 cn12_15 cn13_15 1.002
rcrh12_16 cn12_16 cn12_17 3.3612
rcrv12_16 cn12_16 cn13_16 0.040295
rcrh12_17 cn12_17 cn12_18 3.2454
rcrv12_17 cn12_17 cn13_17 76.096
rcrh12_18 cn12_18 cn12_19 8.5164
rcrv12_18 cn12_18 cn13_18 6.2662
rcrh12_19 cn12_19 cn12_20 1.1299
rcrv12_19 cn12_19 cn13_19 0.74627
rcrh12_20 cn12_20 cn12_21 57.7
rcrv12_20 cn12_20 cn13_20 3.7508
rcrv12_21 cn12_21 cn13_21 0.56683
rcrh13_0 cn13_0 cn13_1 60.786
rcrv13_0 cn13_0 cn14_0 0.034466
rcrh13_1 cn13_1 cn13_2 7.7366
rcrv13_1 cn13_1 cn14_1 5.733
rcrh13_2 cn13_2 cn13_3 3.7983
rcrv13_2 cn13_2 cn14_2 5.6392
rcrh13_3 cn13_3 cn13_4 28.539
rcrv13_3 cn13_3 cn14_3 1.1959
rcrh13_4 cn13_4 cn13_5 0.12794
rcrv13_4 cn13_4 cn14_4 0.18351
rcrh13_5 cn13_5 cn13_6 0.10368
rcrv13_5 cn13_5 cn14_5 2.6404
rcrh13_6 cn13_6 cn13_7 0.42065
rcrv13_6 cn13_6 cn14_6 32.205
rcrh13_7 cn13_7 cn13_8 0.014
rcrv13_7 cn13_7 cn14_7 0.056695
rcrh13_8 cn13_8 cn13_9 0.25379
rcrv13_8 cn13_8 cn14_8 0.15996
rcrh13_9 cn13_9 cn13_10 0.73884
rcrv13_9 cn13_9 cn14_9 2.5481
rcrh13_10 cn13_10 cn13_11 0.91974
rcrv13_10 cn13_10 cn14_10 0.62071
rcrh13_11 cn13_11 cn13_12 0.011752
rcrv13_11 cn13_11 cn14_11 0.010543
rcrh13_12 cn13_12 cn13_13 0.32596
rcrv13_12 cn13_12 cn14_12 80.324
rcrh13_13 cn13_13 cn13_14 0.35207
rcrv13_13 cn13_13 cn14_13 0.42935
rcrh13_14 cn13_14 cn13_15 0.053754
rcrv13_14 cn13_14 cn14_14 2.4196
rcrh13_15 cn13_15 cn13_16 0.037917
rcrv13_15 cn13_15 cn14_15 1.6089
rcrh13_16 cn13_16 cn13_17 0.55176
rcrv13_16 cn13_16 cn14_16 0.055745
rcrh13_17 cn13_17 cn13_18 0.095412
rcrv13_17 cn13_17 cn14_17 3.6819
rcrh13_18 cn13_18 cn13_19 0.33148
rcrv13_18 cn13_18 cn14_18 0.030714
rcrh13_19 cn13_19 cn13_20 44.442
rcrv13_19 cn13_19 cn14_19 88.966
rcrh13_20 cn13_20 cn13_21 26.064
rcrv13_20 cn13_20 cn14_20 3.1928
rcrv13_21 cn13_21 cn14_21 0.02761
rcrh14_0 cn14_0 cn14_1 0.28799
rcrv14_0 cn14_0 cn15_0 0.19308
rcrh14_1 cn14_1 cn14_2 2.6396
rcrv14_1 cn14_1 cn15_1 0.14575
rcrh14_2 cn14_2 cn14_3 0.29946
rcrv14_2 cn14_2 cn15_2 1.9543
rcrh14_3 cn14_3 cn14_4 0.09652
rcrv14_3 cn14_3 cn15_3 57.22
rcrh14_4 cn14_4 cn14_5 32.451
rcrv14_4 cn14_4 cn15_4 48.798
rcrh14_5 cn14_5 cn14_6 8.7874
rcrv14_5 cn14_5 cn15_5 0.01095
rcrh14_6 cn14_6 cn14_7 14.28
rcrv14_6 cn14_6 cn15_6 4.4055
rcrh14_7 cn14_7 cn14_8 37.396
rcrv14_7 cn14_7 cn15_7 6.531
rcrh14_8 cn14_8 cn14_9 18.645
rcrv14_8 cn14_8 cn15_8 62.476
rcrh14_9 cn14_9 cn14_10 6.9985
rcrv14_9 cn14_9 cn15_9 21.725
rcrh14_10 cn14_10 cn14_11 19.867
rcrv14_10 cn14_10 cn15_10 82.302
rcrh14_11 cn14_11 cn14_12 0.80469
rcrv14_11 cn14_11 cn15_11 39.431
rcrh14_12 cn14_12 cn14_13 0.13877
rcrv14_12 cn14_12 cn15_12 24.392
rcrh14_13 cn14_13 cn14_14 2.1861
rcrv14_13 cn14_13 cn15_13 1.4616
rcrh14_14 cn14_14 cn14_15 0.046352
rcrv14_14 cn14_14 cn15_14 2.0511
rcrh14_15 cn14_15 cn14_16 4.1102
rcrv14_15 cn14_15 cn15_15 1.79
rcrh14_16 cn14_16 cn14_17 29.144
rcrv14_16 cn14_16 cn15_16 0.3955
rcrh14_17 cn14_17 cn14_18 0.013147
rcrv14_17 cn14_17 cn15_17 0.19565
rcrh14_18 cn14_18 cn14_19 0.032432
rcrv14_18 cn14_18 cn15_18 8.2061
rcrh14_19 cn14_19 cn14_20 0.012133
rcrv14_19 cn14_19 cn15_19 6.893
rcrh14_20 cn14_20 cn14_21 3.5575
rcrv14_20 cn14_20 cn15_20 4.0947
rcrv14_21 cn14_21 cn15_21 0.66479
rcrh15_0 cn15_0 cn15_1 3.088
rcrv15_0 cn15_0 cn16_0 0.10379
rcrh15_1 cn15_1 cn15_2 0.041186
rcrv15_1 cn15_1 cn16_1 13.133
rcrh15_2 cn15_2 cn15_3 0.13033
rcrv15_2 cn15_2 cn16_2 0.49175
rcrh15_3 cn15_3 cn15_4 1.9923
rcrv15_3 cn15_3 cn16_3 0.018405
rcrh15_4 cn15_4 cn15_5 0.069036
rcrv15_4 cn15_4 cn16_4 0.34543
rcrh15_5 cn15_5 cn15_6 0.072768
rcrv15_5 cn15_5 cn16_5 5.9813
rcrh15_6 cn15_6 cn15_7 37.105
rcrv15_6 cn15_6 cn16_6 2.2721
rcrh15_7 cn15_7 cn15_8 83.341
rcrv15_7 cn15_7 cn16_7 0.022309
rcrh15_8 cn15_8 cn15_9 2.8302
rcrv15_8 cn15_8 cn16_8 2.1074
rcrh15_9 cn15_9 cn15_10 27.063
rcrv15_9 cn15_9 cn16_9 0.61585
rcrh15_10 cn15_10 cn15_11 0.96513
rcrv15_10 cn15_10 cn16_10 0.011365
rcrh15_11 cn15_11 cn15_12 6.392
rcrv15_11 cn15_11 cn16_11 16.312
rcrh15_12 cn15_12 cn15_13 1.1577
rcrv15_12 cn15_12 cn16_12 28.237
rcrh15_13 cn15_13 cn15_14 1.6716
rcrv15_13 cn15_13 cn16_13 46.113
rcrh15_14 cn15_14 cn15_15 0.018684
rcrv15_14 cn15_14 cn16_14 0.37943
rcrh15_15 cn15_15 cn15_16 11.504
rcrv15_15 cn15_15 cn16_15 0.51207
rcrh15_16 cn15_16 cn15_17 2.041
rcrv15_16 cn15_16 cn16_16 0.016679
rcrh15_17 cn15_17 cn15_18 0.12387
rcrv15_17 cn15_17 cn16_17 20.019
rcrh15_18 cn15_18 cn15_19 0.53111
rcrv15_18 cn15_18 cn16_18 0.11321
rcrh15_19 cn15_19 cn15_20 2.9985
rcrv15_19 cn15_19 cn16_19 0.18716
rcrh15_20 cn15_20 cn15_21 81.044
rcrv15_20 cn15_20 cn16_20 16.754
rcrv15_21 cn15_21 cn16_21 0.19383
rcrh16_0 cn16_0 cn16_1 0.14553
rcrv16_0 cn16_0 cn17_0 0.25127
rcrh16_1 cn16_1 cn16_2 2.126
rcrv16_1 cn16_1 cn17_1 0.26332
rcrh16_2 cn16_2 cn16_3 40.257
rcrv16_2 cn16_2 cn17_2 38.679
rcrh16_3 cn16_3 cn16_4 15.618
rcrv16_3 cn16_3 cn17_3 24.155
rcrh16_4 cn16_4 cn16_5 2.6809
rcrv16_4 cn16_4 cn17_4 0.7507
rcrh16_5 cn16_5 cn16_6 0.092602
rcrv16_5 cn16_5 cn17_5 0.57702
rcrh16_6 cn16_6 cn16_7 0.89986
rcrv16_6 cn16_6 cn17_6 4.4468
rcrh16_7 cn16_7 cn16_8 0.011547
rcrv16_7 cn16_7 cn17_7 65.22
rcrh16_8 cn16_8 cn16_9 0.56118
rcrv16_8 cn16_8 cn17_8 0.076466
rcrh16_9 cn16_9 cn16_10 0.26213
rcrv16_9 cn16_9 cn17_9 0.75643
rcrh16_10 cn16_10 cn16_11 0.020835
rcrv16_10 cn16_10 cn17_10 0.73866
rcrh16_11 cn16_11 cn16_12 0.015975
rcrv16_11 cn16_11 cn17_11 24.352
rcrh16_12 cn16_12 cn16_13 0.018113
rcrv16_12 cn16_12 cn17_12 0.13993
rcrh16_13 cn16_13 cn16_14 0.028306
rcrv16_13 cn16_13 cn17_13 0.022343
rcrh16_14 cn16_14 cn16_15 3.6791
rcrv16_14 cn16_14 cn17_14 0.1211
rcrh16_15 cn16_15 cn16_16 2.3388
rcrv16_15 cn16_15 cn17_15 25.679
rcrh16_16 cn16_16 cn16_17 0.02121
rcrv16_16 cn16_16 cn17_16 0.030382
rcrh16_17 cn16_17 cn16_18 1.5384
rcrv16_17 cn16_17 cn17_17 0.1474
rcrh16_18 cn16_18 cn16_19 0.76392
rcrv16_18 cn16_18 cn17_18 0.059424
rcrh16_19 cn16_19 cn16_20 25.688
rcrv16_19 cn16_19 cn17_19 0.92226
rcrh16_20 cn16_20 cn16_21 0.74295
rcrv16_20 cn16_20 cn17_20 3.086
rcrv16_21 cn16_21 cn17_21 0.19857
rcrh17_0 cn17_0 cn17_1 26.089
rcrv17_0 cn17_0 cn18_0 1.0646
rcrh17_1 cn17_1 cn17_2 30.062
rcrv17_1 cn17_1 cn18_1 0.96719
rcrh17_2 cn17_2 cn17_3 0.35974
rcrv17_2 cn17_2 cn18_2 0.17956
rcrh17_3 cn17_3 cn17_4 38.06
rcrv17_3 cn17_3 cn18_3 0.63562
rcrh17_4 cn17_4 cn17_5 72.881
rcrv17_4 cn17_4 cn18_4 0.040853
rcrh17_5 cn17_5 cn17_6 0.013455
rcrv17_5 cn17_5 cn18_5 0.063698
rcrh17_6 cn17_6 cn17_7 1.5303
rcrv17_6 cn17_6 cn18_6 69.104
rcrh17_7 cn17_7 cn17_8 88.285
rcrv17_7 cn17_7 cn18_7 0.29406
rcrh17_8 cn17_8 cn17_9 45.847
rcrv17_8 cn17_8 cn18_8 0.15453
rcrh17_9 cn17_9 cn17_10 79.987
rcrv17_9 cn17_9 cn18_9 0.26918
rcrh17_10 cn17_10 cn17_11 0.26713
rcrv17_10 cn17_10 cn18_10 0.031844
rcrh17_11 cn17_11 cn17_12 0.17586
rcrv17_11 cn17_11 cn18_11 0.18298
rcrh17_12 cn17_12 cn17_13 0.7229
rcrv17_12 cn17_12 cn18_12 3.6166
rcrh17_13 cn17_13 cn17_14 4.3613
rcrv17_13 cn17_13 cn18_13 0.31353
rcrh17_14 cn17_14 cn17_15 1.4887
rcrv17_14 cn17_14 cn18_14 8.0976
rcrh17_15 cn17_15 cn17_16 0.29057
rcrv17_15 cn17_15 cn18_15 1.1484
rcrh17_16 cn17_16 cn17_17 0.28407
rcrv17_16 cn17_16 cn18_16 0.030149
rcrh17_17 cn17_17 cn17_18 2.072
rcrv17_17 cn17_17 cn18_17 0.023885
rcrh17_18 cn17_18 cn17_19 84.05
rcrv17_18 cn17_18 cn18_18 0.01294
rcrh17_19 cn17_19 cn17_20 1.1397
rcrv17_19 cn17_19 cn18_19 1.3848
rcrh17_20 cn17_20 cn17_21 1.9116
rcrv17_20 cn17_20 cn18_20 2.016
rcrv17_21 cn17_21 cn18_21 0.029814
rcrh18_0 cn18_0 cn18_1 1.272
rcrv18_0 cn18_0 cn19_0 65.628
rcrh18_1 cn18_1 cn18_2 1.4798
rcrv18_1 cn18_1 cn19_1 44.141
rcrh18_2 cn18_2 cn18_3 0.40894
rcrv18_2 cn18_2 cn19_2 0.014347
rcrh18_3 cn18_3 cn18_4 0.061888
rcrv18_3 cn18_3 cn19_3 16.409
rcrh18_4 cn18_4 cn18_5 0.51091
rcrv18_4 cn18_4 cn19_4 0.27205
rcrh18_5 cn18_5 cn18_6 0.068644
rcrv18_5 cn18_5 cn19_5 1.6279
rcrh18_6 cn18_6 cn18_7 0.039196
rcrv18_6 cn18_6 cn19_6 0.029747
rcrh18_7 cn18_7 cn18_8 38.273
rcrv18_7 cn18_7 cn19_7 0.92358
rcrh18_8 cn18_8 cn18_9 49.525
rcrv18_8 cn18_8 cn19_8 1.4933
rcrh18_9 cn18_9 cn18_10 0.64314
rcrv18_9 cn18_9 cn19_9 0.11604
rcrh18_10 cn18_10 cn18_11 30.908
rcrv18_10 cn18_10 cn19_10 0.02018
rcrh18_11 cn18_11 cn18_12 2.2793
rcrv18_11 cn18_11 cn19_11 12.75
rcrh18_12 cn18_12 cn18_13 9.7473
rcrv18_12 cn18_12 cn19_12 0.62111
rcrh18_13 cn18_13 cn18_14 0.035547
rcrv18_13 cn18_13 cn19_13 0.016576
rcrh18_14 cn18_14 cn18_15 1.6198
rcrv18_14 cn18_14 cn19_14 0.047372
rcrh18_15 cn18_15 cn18_16 5.9411
rcrv18_15 cn18_15 cn19_15 0.28266
rcrh18_16 cn18_16 cn18_17 0.043261
rcrv18_16 cn18_16 cn19_16 23.663
rcrh18_17 cn18_17 cn18_18 7.7821
rcrv18_17 cn18_17 cn19_17 0.24854
rcrh18_18 cn18_18 cn18_19 0.35084
rcrv18_18 cn18_18 cn19_18 1.4105
rcrh18_19 cn18_19 cn18_20 0.7143
rcrv18_19 cn18_19 cn19_19 0.046045
rcrh18_20 cn18_20 cn18_21 0.016931
rcrv18_20 cn18_20 cn19_20 0.26183
rcrv18_21 cn18_21 cn19_21 0.34735
rcrh19_0 cn19_0 cn19_1 0.13413
rcrv19_0 cn19_0 cn20_0 39.031
rcrh19_1 cn19_1 cn19_2 62.609
rcrv19_1 cn19_1 cn20_1 0.568
rcrh19_2 cn19_2 cn19_3 0.85164
rcrv19_2 cn19_2 cn20_2 19.501
rcrh19_3 cn19_3 cn19_4 3.0974
rcrv19_3 cn19_3 cn20_3 46.255
rcrh19_4 cn19_4 cn19_5 2.0139
rcrv19_4 cn19_4 cn20_4 27.721
rcrh19_5 cn19_5 cn19_6 44.892
rcrv19_5 cn19_5 cn20_5 0.68149
rcrh19_6 cn19_6 cn19_7 0.022886
rcrv19_6 cn19_6 cn20_6 0.36386
rcrh19_7 cn19_7 cn19_8 0.22514
rcrv19_7 cn19_7 cn20_7 49.831
rcrh19_8 cn19_8 cn19_9 1.8627
rcrv19_8 cn19_8 cn20_8 0.65547
rcrh19_9 cn19_9 cn19_10 0.18912
rcrv19_9 cn19_9 cn20_9 0.84976
rcrh19_10 cn19_10 cn19_11 6.0006
rcrv19_10 cn19_10 cn20_10 28.601
rcrh19_11 cn19_11 cn19_12 4.5593
rcrv19_11 cn19_11 cn20_11 0.036837
rcrh19_12 cn19_12 cn19_13 0.30798
rcrv19_12 cn19_12 cn20_12 1.0266
rcrh19_13 cn19_13 cn19_14 0.028251
rcrv19_13 cn19_13 cn20_13 35.888
rcrh19_14 cn19_14 cn19_15 1.0322
rcrv19_14 cn19_14 cn20_14 14.578
rcrh19_15 cn19_15 cn19_16 10.072
rcrv19_15 cn19_15 cn20_15 12.278
rcrh19_16 cn19_16 cn19_17 0.040303
rcrv19_16 cn19_16 cn20_16 0.37718
rcrh19_17 cn19_17 cn19_18 0.29454
rcrv19_17 cn19_17 cn20_17 0.77113
rcrh19_18 cn19_18 cn19_19 0.019908
rcrv19_18 cn19_18 cn20_18 8.3733
rcrh19_19 cn19_19 cn19_20 0.1412
rcrv19_19 cn19_19 cn20_19 28.17
rcrh19_20 cn19_20 cn19_21 18.495
rcrv19_20 cn19_20 cn20_20 5.9805
rcrv19_21 cn19_21 cn20_21 87.024
rcrh20_0 cn20_0 cn20_1 0.039848
rcrv20_0 cn20_0 cn21_0 62.412
rcrh20_1 cn20_1 cn20_2 0.022554
rcrv20_1 cn20_1 cn21_1 0.05519
rcrh20_2 cn20_2 cn20_3 0.91308
rcrv20_2 cn20_2 cn21_2 0.12149
rcrh20_3 cn20_3 cn20_4 0.65365
rcrv20_3 cn20_3 cn21_3 0.062637
rcrh20_4 cn20_4 cn20_5 0.28101
rcrv20_4 cn20_4 cn21_4 0.014571
rcrh20_5 cn20_5 cn20_6 0.024432
rcrv20_5 cn20_5 cn21_5 6.5893
rcrh20_6 cn20_6 cn20_7 0.68363
rcrv20_6 cn20_6 cn21_6 10.852
rcrh20_7 cn20_7 cn20_8 2.7288
rcrv20_7 cn20_7 cn21_7 67.534
rcrh20_8 cn20_8 cn20_9 0.55671
rcrv20_8 cn20_8 cn21_8 2.036
rcrh20_9 cn20_9 cn20_10 0.0797
rcrv20_9 cn20_9 cn21_9 44.03
rcrh20_10 cn20_10 cn20_11 0.029079
rcrv20_10 cn20_10 cn21_10 51.95
rcrh20_11 cn20_11 cn20_12 0.013697
rcrv20_11 cn20_11 cn21_11 5.2514
rcrh20_12 cn20_12 cn20_13 5.1019
rcrv20_12 cn20_12 cn21_12 1.2833
rcrh20_13 cn20_13 cn20_14 3.8802
rcrv20_13 cn20_13 cn21_13 0.022293
rcrh20_14 cn20_14 cn20_15 7.8705
rcrv20_14 cn20_14 cn21_14 0.42301
rcrh20_15 cn20_15 cn20_16 8.7201
rcrv20_15 cn20_15 cn21_15 0.046761
rcrh20_16 cn20_16 cn20_17 50.796
rcrv20_16 cn20_16 cn21_16 0.42332
rcrh20_17 cn20_17 cn20_18 0.29557
rcrv20_17 cn20_17 cn21_17 3.6366
rcrh20_18 cn20_18 cn20_19 2.5958
rcrv20_18 cn20_18 cn21_18 22.279
rcrh20_19 cn20_19 cn20_20 0.046121
rcrv20_19 cn20_19 cn21_19 0.036349
rcrh20_20 cn20_20 cn20_21 5.7006
rcrv20_20 cn20_20 cn21_20 2.1644
rcrv20_21 cn20_21 cn21_21 0.14511
rcrh21_0 cn21_0 cn21_1 0.044466
rcrh21_1 cn21_1 cn21_2 0.011544
rcrh21_2 cn21_2 cn21_3 0.3283
rcrh21_3 cn21_3 cn21_4 0.010761
rcrh21_4 cn21_4 cn21_5 0.3853
rcrh21_5 cn21_5 cn21_6 2.0096
rcrh21_6 cn21_6 cn21_7 0.047863
rcrh21_7 cn21_7 cn21_8 6.4954
rcrh21_8 cn21_8 cn21_9 0.021558
rcrh21_9 cn21_9 cn21_10 3.3955
rcrh21_10 cn21_10 cn21_11 0.73929
rcrh21_11 cn21_11 cn21_12 0.010796
rcrh21_12 cn21_12 cn21_13 2.3408
rcrh21_13 cn21_13 cn21_14 6.763
rcrh21_14 cn21_14 cn21_15 0.28986
rcrh21_15 cn21_15 cn21_16 7.6391
rcrh21_16 cn21_16 cn21_17 56.591
rcrh21_17 cn21_17 cn21_18 26.955
rcrh21_18 cn21_18 cn21_19 43.674
rcrh21_19 cn21_19 cn21_20 0.05288
rcrh21_20 cn21_20 cn21_21 0.011858
rcp0 cp1 cn0_0 0.01
rcp1 cn0_21 0 0.01
rcp2 cn21_0 0 0.01
rcp3 cp2 cn21_21 0.01
vc1 cp1 0 DC 0
vc2 cp2 0 DC 0
ic3 0 cn11_7 DC 0.5
vref ref1 0 DC 1
rm5_5 r_5_5 ref1 1
gf5_5 0 r_5_5 fn5_5 0 1
ga5_5 r_5_5 0 an5_5 0 1
gb5_5 r_5_5 0 bn5_5 0 1
gc5_5 r_5_5 0 cn5_5 0 1
rm11_19 r_11_19 ref1 1
gf11_19 0 r_11_19 fn11_19 0 1
ga11_19 r_11_19 0 an11_19 0 1
gb11_19 r_11_19 0 bn11_19 0 1
gc11_19 r_11_19 0 cn11_19 0 1
rm19_11 r_19_11 ref1 1
gf19_11 0 r_19_11 fn19_11 0 1
ga19_11 r_19_11 0 an19_11 0 1
gb19_11 r_19_11 0 bn19_11 0 1
gc19_11 r_19_11 0 cn19_11 0 1
rm20_2 r_20_2 ref1 1
gf20_2 0 r_20_2 fn20_2 0 1
ga20_2 r_20_2 0 an20_2 0 1
gb20_2 r_20_2 0 bn20_2 0 1
gc20_2 r_20_2 0 cn20_2 0 1
.op
.end
