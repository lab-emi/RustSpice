Diode-resistor mesh 8x8 (R 10..1000 ohm links, 16 diode-resistor legs to ground), random numbering, 5 V feed
* bench.id: acc_dc_diode_resistor_mesh_8x8
* bench.group: accuracy
* bench.title: Diode-resistor mesh 8x8 (R 10..1000 ohm links, 16 diode-resistor legs to ground), random numbering, 5 V feed
* bench.probes: v(n7_7), v(n4_4), v(n0_0), i(v1)
* bench.tol.abs: 1e-12
* bench.oracle: dc_nonlinear(gmin=1e-12)
* bench.size: 96
* bench.tags: nonlinear, op, diode, mesh, random_numbering
* bench.note: tol.abs tightened to 1e-12 A (the default 1e-9 A would be 1e-5 relative on mA currents)
Rv2_3 n2_3 n3_3 392.2
Rh5_1 n5_1 n5_2 26.04
V1 vdd 0 5
Rh3_6 n3_6 n3_7 83.56
Rv1_6 n1_6 n2_6 29.67
Rv3_6 n3_6 n4_6 136.6
Rh3_5 n3_5 n3_6 583
Rh2_5 n2_5 n2_6 335.6
Rh3_0 n3_0 n3_1 21.01
D0_0 n0_0 g0_0 dm
Rg4_0 g4_0 0 1700
Rh0_5 n0_5 n0_6 145.3
Rh6_6 n6_6 n6_7 22.07
Rh1_2 n1_2 n1_3 34.39
Rv1_2 n1_2 n2_2 11.8
Rv3_5 n3_5 n4_5 630.1
Rg0_0 g0_0 0 233.1
D4_0 n4_0 g4_0 dm
Rh5_5 n5_5 n5_6 24.14
Rv0_0 n0_0 n1_0 786.4
Rh6_0 n6_0 n6_1 28.39
Rv1_7 n1_7 n2_7 11.16
Rv4_7 n4_7 n5_7 200.8
Rv0_2 n0_2 n1_2 296.4
Rh3_4 n3_4 n3_5 460.3
Rv0_6 n0_6 n1_6 61.24
Rh2_3 n2_3 n2_4 612.6
Rv2_4 n2_4 n3_4 650.4
Rh4_5 n4_5 n4_6 821.7
Rh4_1 n4_1 n4_2 27.77
D7_1 n7_1 g7_1 dm
Rh3_1 n3_1 n3_2 269.3
Rh6_3 n6_3 n6_4 26.36
Rv3_4 n3_4 n4_4 51.03
Rg7_5 g7_5 0 3019
Rh7_5 n7_5 n7_6 423.4
D0_4 n0_4 g0_4 dm
Rh7_4 n7_4 n7_5 32.46
Rh4_2 n4_2 n4_3 250.7
Rg2_6 g2_6 0 200.8
Rh0_0 n0_0 n0_1 816.7
Rin vdd n0_0 100
Rh6_2 n6_2 n6_3 510.4
Rh4_4 n4_4 n4_5 664.9
Rv2_6 n2_6 n3_6 916.1
Rh0_3 n0_3 n0_4 218.5
Rh6_5 n6_5 n6_6 11.58
Rh4_3 n4_3 n4_4 654.5
Rv2_7 n2_7 n3_7 839.1
Rh1_6 n1_6 n1_7 132.1
D3_5 n3_5 g3_5 dm
Rv6_3 n6_3 n7_3 577
Rv4_5 n4_5 n5_5 258.5
Rg3_1 g3_1 0 118.2
Rv5_5 n5_5 n6_5 308.7
Rv4_4 n4_4 n5_4 41.6
Rh2_6 n2_6 n2_7 51
Rh1_3 n1_3 n1_4 11.35
Rg1_3 g1_3 0 590.4
D5_3 n5_3 g5_3 dm
Rg5_3 g5_3 0 168.4
Rg1_7 g1_7 0 122
Rg3_5 g3_5 0 488
D6_6 n6_6 g6_6 dm
Rv4_6 n4_6 n5_6 108.5
Rh3_3 n3_3 n3_4 707.4
Rh5_0 n5_0 n5_1 149.9
Rh6_4 n6_4 n6_5 70.12
Rv3_2 n3_2 n4_2 95.51
Rv1_3 n1_3 n2_3 85.07
Rv5_4 n5_4 n6_4 653.6
Rv6_1 n6_1 n7_1 110.8
D7_5 n7_5 g7_5 dm
Rv3_7 n3_7 n4_7 692.9
Rv4_0 n4_0 n5_0 94.02
Rg5_7 g5_7 0 472.5
Rv2_1 n2_1 n3_1 994
Rh3_2 n3_2 n3_3 115
Rg2_2 g2_2 0 9550
Rv0_7 n0_7 n1_7 279.3
Rv5_7 n5_7 n6_7 35.17
Rv2_0 n2_0 n3_0 18.77
Rv0_1 n0_1 n1_1 14.78
Rv3_3 n3_3 n4_3 100.4
Rv4_2 n4_2 n5_2 21.49
Rv4_3 n4_3 n5_3 34.38
Rh7_1 n7_1 n7_2 11.24
Rv5_2 n5_2 n6_2 176.4
Rg7_1 g7_1 0 3404
Rv5_6 n5_6 n6_6 202.2
Rv0_4 n0_4 n1_4 163.5
Rh5_2 n5_2 n5_3 738.4
Rh4_0 n4_0 n4_1 280.3
Rv1_1 n1_1 n2_1 77.57
Rh2_2 n2_2 n2_3 223.3
D6_2 n6_2 g6_2 dm
Rh2_0 n2_0 n2_1 44.7
D2_6 n2_6 g2_6 dm
Rh0_1 n0_1 n0_2 12.97
D2_2 n2_2 g2_2 dm
Rg4_4 g4_4 0 3054
Rh7_2 n7_2 n7_3 287.6
Rh0_2 n0_2 n0_3 468.8
Rv3_0 n3_0 n4_0 322.1
Rv5_0 n5_0 n6_0 42.04
D1_7 n1_7 g1_7 dm
Rv6_5 n6_5 n7_5 53.05
Rh2_1 n2_1 n2_2 104.8
Rv0_3 n0_3 n1_3 41.33
Rh6_1 n6_1 n6_2 16.31
Rv5_1 n5_1 n6_1 105.6
Rv3_1 n3_1 n4_1 83.72
Rv0_5 n0_5 n1_5 20.74
Rh0_6 n0_6 n0_7 72.67
Rh1_5 n1_5 n1_6 607.5
Rv6_6 n6_6 n7_6 221.6
Rv4_1 n4_1 n5_1 44.6
Rv6_0 n6_0 n7_0 563.6
Rv6_2 n6_2 n7_2 30.88
Rh5_4 n5_4 n5_5 283.1
Rg0_4 g0_4 0 2415
Rg6_6 g6_6 0 789.4
Rv1_5 n1_5 n2_5 112.6
Rh2_4 n2_4 n2_5 294.3
D3_1 n3_1 g3_1 dm
Rv1_4 n1_4 n2_4 57.55
Rh1_1 n1_1 n1_2 122.6
Rh4_6 n4_6 n4_7 102
Rg6_2 g6_2 0 115.2
Rh1_0 n1_0 n1_1 976.4
Rv6_4 n6_4 n7_4 271.6
Rv6_7 n6_7 n7_7 14.65
Rv2_2 n2_2 n3_2 23.1
D5_7 n5_7 g5_7 dm
Rh5_3 n5_3 n5_4 14.15
D4_4 n4_4 g4_4 dm
Rh7_6 n7_6 n7_7 20.62
Rh7_3 n7_3 n7_4 11.02
D1_3 n1_3 g1_3 dm
Rh7_0 n7_0 n7_1 811.2
Rv5_3 n5_3 n6_3 437.3
Rh5_6 n5_6 n5_7 13.11
Rv1_0 n1_0 n2_0 792.1
Rv2_5 n2_5 n3_5 379.7
Rh1_4 n1_4 n1_5 43.34
Rh0_4 n0_4 n0_5 162.9
.model dm D(IS=1e-14 N=1.2)
.op
.end
