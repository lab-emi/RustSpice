RC mesh 8x8, pulse drive, 5e4 steps (67 vectors per row)
* bench.id: perf_out_rc_mesh8x8_pulse_5e4
* bench.group: performance
* bench.title: RC mesh 8x8, pulse drive, 5e4 steps (67 vectors per row)
* bench.probes: v(n0_0), v(n4_4), v(n7_7), i(v1)
* bench.tol.norm: 2e-3
* bench.expect: match
* bench.ref: reltol=1e-6 abstol=1e-15 vntol=1e-9
* bench.ref.tmax: 0.5n
* bench.ng.solver: both
* bench.timing: yes
* bench.size: 66
* bench.est_rss_mib: 50
* bench.tags: linear, tran, long, mesh, wide_output, rawfile_write
* bench.note: 5e4 output rows of 67 vectors (about 27 MB of rawfile) from a 66-unknown 2-D linear system with the step equal to the node RC time constant; tstop is 50000.5 steps so the last step is a legitimate half step
V1 in 0 PULSE(0 1 5n 100n 100n 2400n 5u)
Rin in n0_0 1k
C0_0 n0_0 0 1p
Rh0_0 n0_0 n0_1 1k
Rv0_0 n0_0 n1_0 1k
C0_1 n0_1 0 1p
Rh0_1 n0_1 n0_2 1k
Rv0_1 n0_1 n1_1 1k
C0_2 n0_2 0 1p
Rh0_2 n0_2 n0_3 1k
Rv0_2 n0_2 n1_2 1k
C0_3 n0_3 0 1p
Rh0_3 n0_3 n0_4 1k
Rv0_3 n0_3 n1_3 1k
C0_4 n0_4 0 1p
Rh0_4 n0_4 n0_5 1k
Rv0_4 n0_4 n1_4 1k
C0_5 n0_5 0 1p
Rh0_5 n0_5 n0_6 1k
Rv0_5 n0_5 n1_5 1k
C0_6 n0_6 0 1p
Rh0_6 n0_6 n0_7 1k
Rv0_6 n0_6 n1_6 1k
C0_7 n0_7 0 1p
Rv0_7 n0_7 n1_7 1k
C1_0 n1_0 0 1p
Rh1_0 n1_0 n1_1 1k
Rv1_0 n1_0 n2_0 1k
C1_1 n1_1 0 1p
Rh1_1 n1_1 n1_2 1k
Rv1_1 n1_1 n2_1 1k
C1_2 n1_2 0 1p
Rh1_2 n1_2 n1_3 1k
Rv1_2 n1_2 n2_2 1k
C1_3 n1_3 0 1p
Rh1_3 n1_3 n1_4 1k
Rv1_3 n1_3 n2_3 1k
C1_4 n1_4 0 1p
Rh1_4 n1_4 n1_5 1k
Rv1_4 n1_4 n2_4 1k
C1_5 n1_5 0 1p
Rh1_5 n1_5 n1_6 1k
Rv1_5 n1_5 n2_5 1k
C1_6 n1_6 0 1p
Rh1_6 n1_6 n1_7 1k
Rv1_6 n1_6 n2_6 1k
C1_7 n1_7 0 1p
Rv1_7 n1_7 n2_7 1k
C2_0 n2_0 0 1p
Rh2_0 n2_0 n2_1 1k
Rv2_0 n2_0 n3_0 1k
C2_1 n2_1 0 1p
Rh2_1 n2_1 n2_2 1k
Rv2_1 n2_1 n3_1 1k
C2_2 n2_2 0 1p
Rh2_2 n2_2 n2_3 1k
Rv2_2 n2_2 n3_2 1k
C2_3 n2_3 0 1p
Rh2_3 n2_3 n2_4 1k
Rv2_3 n2_3 n3_3 1k
C2_4 n2_4 0 1p
Rh2_4 n2_4 n2_5 1k
Rv2_4 n2_4 n3_4 1k
C2_5 n2_5 0 1p
Rh2_5 n2_5 n2_6 1k
Rv2_5 n2_5 n3_5 1k
C2_6 n2_6 0 1p
Rh2_6 n2_6 n2_7 1k
Rv2_6 n2_6 n3_6 1k
C2_7 n2_7 0 1p
Rv2_7 n2_7 n3_7 1k
C3_0 n3_0 0 1p
Rh3_0 n3_0 n3_1 1k
Rv3_0 n3_0 n4_0 1k
C3_1 n3_1 0 1p
Rh3_1 n3_1 n3_2 1k
Rv3_1 n3_1 n4_1 1k
C3_2 n3_2 0 1p
Rh3_2 n3_2 n3_3 1k
Rv3_2 n3_2 n4_2 1k
C3_3 n3_3 0 1p
Rh3_3 n3_3 n3_4 1k
Rv3_3 n3_3 n4_3 1k
C3_4 n3_4 0 1p
Rh3_4 n3_4 n3_5 1k
Rv3_4 n3_4 n4_4 1k
C3_5 n3_5 0 1p
Rh3_5 n3_5 n3_6 1k
Rv3_5 n3_5 n4_5 1k
C3_6 n3_6 0 1p
Rh3_6 n3_6 n3_7 1k
Rv3_6 n3_6 n4_6 1k
C3_7 n3_7 0 1p
Rv3_7 n3_7 n4_7 1k
C4_0 n4_0 0 1p
Rh4_0 n4_0 n4_1 1k
Rv4_0 n4_0 n5_0 1k
C4_1 n4_1 0 1p
Rh4_1 n4_1 n4_2 1k
Rv4_1 n4_1 n5_1 1k
C4_2 n4_2 0 1p
Rh4_2 n4_2 n4_3 1k
Rv4_2 n4_2 n5_2 1k
C4_3 n4_3 0 1p
Rh4_3 n4_3 n4_4 1k
Rv4_3 n4_3 n5_3 1k
C4_4 n4_4 0 1p
Rh4_4 n4_4 n4_5 1k
Rv4_4 n4_4 n5_4 1k
C4_5 n4_5 0 1p
Rh4_5 n4_5 n4_6 1k
Rv4_5 n4_5 n5_5 1k
C4_6 n4_6 0 1p
Rh4_6 n4_6 n4_7 1k
Rv4_6 n4_6 n5_6 1k
C4_7 n4_7 0 1p
Rv4_7 n4_7 n5_7 1k
C5_0 n5_0 0 1p
Rh5_0 n5_0 n5_1 1k
Rv5_0 n5_0 n6_0 1k
C5_1 n5_1 0 1p
Rh5_1 n5_1 n5_2 1k
Rv5_1 n5_1 n6_1 1k
C5_2 n5_2 0 1p
Rh5_2 n5_2 n5_3 1k
Rv5_2 n5_2 n6_2 1k
C5_3 n5_3 0 1p
Rh5_3 n5_3 n5_4 1k
Rv5_3 n5_3 n6_3 1k
C5_4 n5_4 0 1p
Rh5_4 n5_4 n5_5 1k
Rv5_4 n5_4 n6_4 1k
C5_5 n5_5 0 1p
Rh5_5 n5_5 n5_6 1k
Rv5_5 n5_5 n6_5 1k
C5_6 n5_6 0 1p
Rh5_6 n5_6 n5_7 1k
Rv5_6 n5_6 n6_6 1k
C5_7 n5_7 0 1p
Rv5_7 n5_7 n6_7 1k
C6_0 n6_0 0 1p
Rh6_0 n6_0 n6_1 1k
Rv6_0 n6_0 n7_0 1k
C6_1 n6_1 0 1p
Rh6_1 n6_1 n6_2 1k
Rv6_1 n6_1 n7_1 1k
C6_2 n6_2 0 1p
Rh6_2 n6_2 n6_3 1k
Rv6_2 n6_2 n7_2 1k
C6_3 n6_3 0 1p
Rh6_3 n6_3 n6_4 1k
Rv6_3 n6_3 n7_3 1k
C6_4 n6_4 0 1p
Rh6_4 n6_4 n6_5 1k
Rv6_4 n6_4 n7_4 1k
C6_5 n6_5 0 1p
Rh6_5 n6_5 n6_6 1k
Rv6_5 n6_5 n7_5 1k
C6_6 n6_6 0 1p
Rh6_6 n6_6 n6_7 1k
Rv6_6 n6_6 n7_6 1k
C6_7 n6_7 0 1p
Rv6_7 n6_7 n7_7 1k
C7_0 n7_0 0 1p
Rh7_0 n7_0 n7_1 1k
C7_1 n7_1 0 1p
Rh7_1 n7_1 n7_2 1k
C7_2 n7_2 0 1p
Rh7_2 n7_2 n7_3 1k
C7_3 n7_3 0 1p
Rh7_3 n7_3 n7_4 1k
C7_4 n7_4 0 1p
Rh7_4 n7_4 n7_5 1k
C7_5 n7_5 0 1p
Rh7_5 n7_5 n7_6 1k
C7_6 n7_6 0 1p
Rh7_6 n7_6 n7_7 1k
C7_7 n7_7 0 1p
.tran 1n 50.0005u
.end
