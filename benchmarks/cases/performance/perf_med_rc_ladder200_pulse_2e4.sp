RC ladder with 200 stages, pulse drive, 2e4 steps
* bench.id: perf_med_rc_ladder200_pulse_2e4
* bench.group: performance
* bench.title: RC ladder with 200 stages, pulse drive, 2e4 steps
* bench.probes: v(n1), v(n100), v(n200)
* bench.tol.norm: 2e-3
* bench.expect: match
* bench.ref: reltol=1e-6 abstol=1e-15 vntol=1e-9
* bench.ref.tmax: 5n
* bench.ng.solver: both
* bench.timing: yes
* bench.size: 202
* bench.est_rss_mib: 60
* bench.tags: linear, tran, ladder, medium, wide_output
* bench.note: tridiagonal 202-unknown system, 2e4 steps, 203 vectors per output row (wide rawfile rows); the step is far above the fastest RC time constant, so the source current is not probed (its one-off trapezoid ringing at the ramp start dominates a swing-normalised metric)
V1 in 0 PULSE(0 1 100n 2u 2u 150u 300u)
R1 in n1 100
C1 n1 0 100p
R2 n1 n2 100
C2 n2 0 100p
R3 n2 n3 100
C3 n3 0 100p
R4 n3 n4 100
C4 n4 0 100p
R5 n4 n5 100
C5 n5 0 100p
R6 n5 n6 100
C6 n6 0 100p
R7 n6 n7 100
C7 n7 0 100p
R8 n7 n8 100
C8 n8 0 100p
R9 n8 n9 100
C9 n9 0 100p
R10 n9 n10 100
C10 n10 0 100p
R11 n10 n11 100
C11 n11 0 100p
R12 n11 n12 100
C12 n12 0 100p
R13 n12 n13 100
C13 n13 0 100p
R14 n13 n14 100
C14 n14 0 100p
R15 n14 n15 100
C15 n15 0 100p
R16 n15 n16 100
C16 n16 0 100p
R17 n16 n17 100
C17 n17 0 100p
R18 n17 n18 100
C18 n18 0 100p
R19 n18 n19 100
C19 n19 0 100p
R20 n19 n20 100
C20 n20 0 100p
R21 n20 n21 100
C21 n21 0 100p
R22 n21 n22 100
C22 n22 0 100p
R23 n22 n23 100
C23 n23 0 100p
R24 n23 n24 100
C24 n24 0 100p
R25 n24 n25 100
C25 n25 0 100p
R26 n25 n26 100
C26 n26 0 100p
R27 n26 n27 100
C27 n27 0 100p
R28 n27 n28 100
C28 n28 0 100p
R29 n28 n29 100
C29 n29 0 100p
R30 n29 n30 100
C30 n30 0 100p
R31 n30 n31 100
C31 n31 0 100p
R32 n31 n32 100
C32 n32 0 100p
R33 n32 n33 100
C33 n33 0 100p
R34 n33 n34 100
C34 n34 0 100p
R35 n34 n35 100
C35 n35 0 100p
R36 n35 n36 100
C36 n36 0 100p
R37 n36 n37 100
C37 n37 0 100p
R38 n37 n38 100
C38 n38 0 100p
R39 n38 n39 100
C39 n39 0 100p
R40 n39 n40 100
C40 n40 0 100p
R41 n40 n41 100
C41 n41 0 100p
R42 n41 n42 100
C42 n42 0 100p
R43 n42 n43 100
C43 n43 0 100p
R44 n43 n44 100
C44 n44 0 100p
R45 n44 n45 100
C45 n45 0 100p
R46 n45 n46 100
C46 n46 0 100p
R47 n46 n47 100
C47 n47 0 100p
R48 n47 n48 100
C48 n48 0 100p
R49 n48 n49 100
C49 n49 0 100p
R50 n49 n50 100
C50 n50 0 100p
R51 n50 n51 100
C51 n51 0 100p
R52 n51 n52 100
C52 n52 0 100p
R53 n52 n53 100
C53 n53 0 100p
R54 n53 n54 100
C54 n54 0 100p
R55 n54 n55 100
C55 n55 0 100p
R56 n55 n56 100
C56 n56 0 100p
R57 n56 n57 100
C57 n57 0 100p
R58 n57 n58 100
C58 n58 0 100p
R59 n58 n59 100
C59 n59 0 100p
R60 n59 n60 100
C60 n60 0 100p
R61 n60 n61 100
C61 n61 0 100p
R62 n61 n62 100
C62 n62 0 100p
R63 n62 n63 100
C63 n63 0 100p
R64 n63 n64 100
C64 n64 0 100p
R65 n64 n65 100
C65 n65 0 100p
R66 n65 n66 100
C66 n66 0 100p
R67 n66 n67 100
C67 n67 0 100p
R68 n67 n68 100
C68 n68 0 100p
R69 n68 n69 100
C69 n69 0 100p
R70 n69 n70 100
C70 n70 0 100p
R71 n70 n71 100
C71 n71 0 100p
R72 n71 n72 100
C72 n72 0 100p
R73 n72 n73 100
C73 n73 0 100p
R74 n73 n74 100
C74 n74 0 100p
R75 n74 n75 100
C75 n75 0 100p
R76 n75 n76 100
C76 n76 0 100p
R77 n76 n77 100
C77 n77 0 100p
R78 n77 n78 100
C78 n78 0 100p
R79 n78 n79 100
C79 n79 0 100p
R80 n79 n80 100
C80 n80 0 100p
R81 n80 n81 100
C81 n81 0 100p
R82 n81 n82 100
C82 n82 0 100p
R83 n82 n83 100
C83 n83 0 100p
R84 n83 n84 100
C84 n84 0 100p
R85 n84 n85 100
C85 n85 0 100p
R86 n85 n86 100
C86 n86 0 100p
R87 n86 n87 100
C87 n87 0 100p
R88 n87 n88 100
C88 n88 0 100p
R89 n88 n89 100
C89 n89 0 100p
R90 n89 n90 100
C90 n90 0 100p
R91 n90 n91 100
C91 n91 0 100p
R92 n91 n92 100
C92 n92 0 100p
R93 n92 n93 100
C93 n93 0 100p
R94 n93 n94 100
C94 n94 0 100p
R95 n94 n95 100
C95 n95 0 100p
R96 n95 n96 100
C96 n96 0 100p
R97 n96 n97 100
C97 n97 0 100p
R98 n97 n98 100
C98 n98 0 100p
R99 n98 n99 100
C99 n99 0 100p
R100 n99 n100 100
C100 n100 0 100p
R101 n100 n101 100
C101 n101 0 100p
R102 n101 n102 100
C102 n102 0 100p
R103 n102 n103 100
C103 n103 0 100p
R104 n103 n104 100
C104 n104 0 100p
R105 n104 n105 100
C105 n105 0 100p
R106 n105 n106 100
C106 n106 0 100p
R107 n106 n107 100
C107 n107 0 100p
R108 n107 n108 100
C108 n108 0 100p
R109 n108 n109 100
C109 n109 0 100p
R110 n109 n110 100
C110 n110 0 100p
R111 n110 n111 100
C111 n111 0 100p
R112 n111 n112 100
C112 n112 0 100p
R113 n112 n113 100
C113 n113 0 100p
R114 n113 n114 100
C114 n114 0 100p
R115 n114 n115 100
C115 n115 0 100p
R116 n115 n116 100
C116 n116 0 100p
R117 n116 n117 100
C117 n117 0 100p
R118 n117 n118 100
C118 n118 0 100p
R119 n118 n119 100
C119 n119 0 100p
R120 n119 n120 100
C120 n120 0 100p
R121 n120 n121 100
C121 n121 0 100p
R122 n121 n122 100
C122 n122 0 100p
R123 n122 n123 100
C123 n123 0 100p
R124 n123 n124 100
C124 n124 0 100p
R125 n124 n125 100
C125 n125 0 100p
R126 n125 n126 100
C126 n126 0 100p
R127 n126 n127 100
C127 n127 0 100p
R128 n127 n128 100
C128 n128 0 100p
R129 n128 n129 100
C129 n129 0 100p
R130 n129 n130 100
C130 n130 0 100p
R131 n130 n131 100
C131 n131 0 100p
R132 n131 n132 100
C132 n132 0 100p
R133 n132 n133 100
C133 n133 0 100p
R134 n133 n134 100
C134 n134 0 100p
R135 n134 n135 100
C135 n135 0 100p
R136 n135 n136 100
C136 n136 0 100p
R137 n136 n137 100
C137 n137 0 100p
R138 n137 n138 100
C138 n138 0 100p
R139 n138 n139 100
C139 n139 0 100p
R140 n139 n140 100
C140 n140 0 100p
R141 n140 n141 100
C141 n141 0 100p
R142 n141 n142 100
C142 n142 0 100p
R143 n142 n143 100
C143 n143 0 100p
R144 n143 n144 100
C144 n144 0 100p
R145 n144 n145 100
C145 n145 0 100p
R146 n145 n146 100
C146 n146 0 100p
R147 n146 n147 100
C147 n147 0 100p
R148 n147 n148 100
C148 n148 0 100p
R149 n148 n149 100
C149 n149 0 100p
R150 n149 n150 100
C150 n150 0 100p
R151 n150 n151 100
C151 n151 0 100p
R152 n151 n152 100
C152 n152 0 100p
R153 n152 n153 100
C153 n153 0 100p
R154 n153 n154 100
C154 n154 0 100p
R155 n154 n155 100
C155 n155 0 100p
R156 n155 n156 100
C156 n156 0 100p
R157 n156 n157 100
C157 n157 0 100p
R158 n157 n158 100
C158 n158 0 100p
R159 n158 n159 100
C159 n159 0 100p
R160 n159 n160 100
C160 n160 0 100p
R161 n160 n161 100
C161 n161 0 100p
R162 n161 n162 100
C162 n162 0 100p
R163 n162 n163 100
C163 n163 0 100p
R164 n163 n164 100
C164 n164 0 100p
R165 n164 n165 100
C165 n165 0 100p
R166 n165 n166 100
C166 n166 0 100p
R167 n166 n167 100
C167 n167 0 100p
R168 n167 n168 100
C168 n168 0 100p
R169 n168 n169 100
C169 n169 0 100p
R170 n169 n170 100
C170 n170 0 100p
R171 n170 n171 100
C171 n171 0 100p
R172 n171 n172 100
C172 n172 0 100p
R173 n172 n173 100
C173 n173 0 100p
R174 n173 n174 100
C174 n174 0 100p
R175 n174 n175 100
C175 n175 0 100p
R176 n175 n176 100
C176 n176 0 100p
R177 n176 n177 100
C177 n177 0 100p
R178 n177 n178 100
C178 n178 0 100p
R179 n178 n179 100
C179 n179 0 100p
R180 n179 n180 100
C180 n180 0 100p
R181 n180 n181 100
C181 n181 0 100p
R182 n181 n182 100
C182 n182 0 100p
R183 n182 n183 100
C183 n183 0 100p
R184 n183 n184 100
C184 n184 0 100p
R185 n184 n185 100
C185 n185 0 100p
R186 n185 n186 100
C186 n186 0 100p
R187 n186 n187 100
C187 n187 0 100p
R188 n187 n188 100
C188 n188 0 100p
R189 n188 n189 100
C189 n189 0 100p
R190 n189 n190 100
C190 n190 0 100p
R191 n190 n191 100
C191 n191 0 100p
R192 n191 n192 100
C192 n192 0 100p
R193 n192 n193 100
C193 n193 0 100p
R194 n193 n194 100
C194 n194 0 100p
R195 n194 n195 100
C195 n195 0 100p
R196 n195 n196 100
C196 n196 0 100p
R197 n196 n197 100
C197 n197 0 100p
R198 n197 n198 100
C198 n198 0 100p
R199 n198 n199 100
C199 n199 0 100p
R200 n199 n200 100
C200 n200 0 100p
.tran 20n 400.01u
.end
