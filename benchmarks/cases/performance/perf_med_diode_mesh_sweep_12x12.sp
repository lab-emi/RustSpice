Diode-resistor mesh 12x12, 61-point source sweep
* bench.id: perf_med_diode_mesh_sweep_12x12
* bench.group: performance
* bench.title: Diode-resistor mesh 12x12, 61-point source sweep
* bench.probes: v(n0_0), v(n6_6), v(n11_11), i(v1)
* bench.tol.rel: 1e-6
* bench.tol.abs: 1e-9
* bench.expect: match
* bench.oracle: dc_nonlinear
* bench.ng.solver: both
* bench.timing: yes
* bench.size: 146
* bench.est_rss_mib: 10
* bench.tags: nonlinear, dc, sweep, mesh, diode, medium
* bench.note: 146-unknown nonlinear mesh swept over 61 points: repeated Newton solves reuse the symbolic factorisation
.model dm D(IS=1e-14 N=1)
V1 in 0 3
Rin in n0_0 100
D0_0 n0_0 0 dm
Rh0_0 n0_0 n0_1 100
Rv0_0 n0_0 n1_0 100
D0_1 n0_1 0 dm
Rh0_1 n0_1 n0_2 100
Rv0_1 n0_1 n1_1 100
D0_2 n0_2 0 dm
Rh0_2 n0_2 n0_3 100
Rv0_2 n0_2 n1_2 100
D0_3 n0_3 0 dm
Rh0_3 n0_3 n0_4 100
Rv0_3 n0_3 n1_3 100
D0_4 n0_4 0 dm
Rh0_4 n0_4 n0_5 100
Rv0_4 n0_4 n1_4 100
D0_5 n0_5 0 dm
Rh0_5 n0_5 n0_6 100
Rv0_5 n0_5 n1_5 100
D0_6 n0_6 0 dm
Rh0_6 n0_6 n0_7 100
Rv0_6 n0_6 n1_6 100
D0_7 n0_7 0 dm
Rh0_7 n0_7 n0_8 100
Rv0_7 n0_7 n1_7 100
D0_8 n0_8 0 dm
Rh0_8 n0_8 n0_9 100
Rv0_8 n0_8 n1_8 100
D0_9 n0_9 0 dm
Rh0_9 n0_9 n0_10 100
Rv0_9 n0_9 n1_9 100
D0_10 n0_10 0 dm
Rh0_10 n0_10 n0_11 100
Rv0_10 n0_10 n1_10 100
D0_11 n0_11 0 dm
Rv0_11 n0_11 n1_11 100
D1_0 n1_0 0 dm
Rh1_0 n1_0 n1_1 100
Rv1_0 n1_0 n2_0 100
D1_1 n1_1 0 dm
Rh1_1 n1_1 n1_2 100
Rv1_1 n1_1 n2_1 100
D1_2 n1_2 0 dm
Rh1_2 n1_2 n1_3 100
Rv1_2 n1_2 n2_2 100
D1_3 n1_3 0 dm
Rh1_3 n1_3 n1_4 100
Rv1_3 n1_3 n2_3 100
D1_4 n1_4 0 dm
Rh1_4 n1_4 n1_5 100
Rv1_4 n1_4 n2_4 100
D1_5 n1_5 0 dm
Rh1_5 n1_5 n1_6 100
Rv1_5 n1_5 n2_5 100
D1_6 n1_6 0 dm
Rh1_6 n1_6 n1_7 100
Rv1_6 n1_6 n2_6 100
D1_7 n1_7 0 dm
Rh1_7 n1_7 n1_8 100
Rv1_7 n1_7 n2_7 100
D1_8 n1_8 0 dm
Rh1_8 n1_8 n1_9 100
Rv1_8 n1_8 n2_8 100
D1_9 n1_9 0 dm
Rh1_9 n1_9 n1_10 100
Rv1_9 n1_9 n2_9 100
D1_10 n1_10 0 dm
Rh1_10 n1_10 n1_11 100
Rv1_10 n1_10 n2_10 100
D1_11 n1_11 0 dm
Rv1_11 n1_11 n2_11 100
D2_0 n2_0 0 dm
Rh2_0 n2_0 n2_1 100
Rv2_0 n2_0 n3_0 100
D2_1 n2_1 0 dm
Rh2_1 n2_1 n2_2 100
Rv2_1 n2_1 n3_1 100
D2_2 n2_2 0 dm
Rh2_2 n2_2 n2_3 100
Rv2_2 n2_2 n3_2 100
D2_3 n2_3 0 dm
Rh2_3 n2_3 n2_4 100
Rv2_3 n2_3 n3_3 100
D2_4 n2_4 0 dm
Rh2_4 n2_4 n2_5 100
Rv2_4 n2_4 n3_4 100
D2_5 n2_5 0 dm
Rh2_5 n2_5 n2_6 100
Rv2_5 n2_5 n3_5 100
D2_6 n2_6 0 dm
Rh2_6 n2_6 n2_7 100
Rv2_6 n2_6 n3_6 100
D2_7 n2_7 0 dm
Rh2_7 n2_7 n2_8 100
Rv2_7 n2_7 n3_7 100
D2_8 n2_8 0 dm
Rh2_8 n2_8 n2_9 100
Rv2_8 n2_8 n3_8 100
D2_9 n2_9 0 dm
Rh2_9 n2_9 n2_10 100
Rv2_9 n2_9 n3_9 100
D2_10 n2_10 0 dm
Rh2_10 n2_10 n2_11 100
Rv2_10 n2_10 n3_10 100
D2_11 n2_11 0 dm
Rv2_11 n2_11 n3_11 100
D3_0 n3_0 0 dm
Rh3_0 n3_0 n3_1 100
Rv3_0 n3_0 n4_0 100
D3_1 n3_1 0 dm
Rh3_1 n3_1 n3_2 100
Rv3_1 n3_1 n4_1 100
D3_2 n3_2 0 dm
Rh3_2 n3_2 n3_3 100
Rv3_2 n3_2 n4_2 100
D3_3 n3_3 0 dm
Rh3_3 n3_3 n3_4 100
Rv3_3 n3_3 n4_3 100
D3_4 n3_4 0 dm
Rh3_4 n3_4 n3_5 100
Rv3_4 n3_4 n4_4 100
D3_5 n3_5 0 dm
Rh3_5 n3_5 n3_6 100
Rv3_5 n3_5 n4_5 100
D3_6 n3_6 0 dm
Rh3_6 n3_6 n3_7 100
Rv3_6 n3_6 n4_6 100
D3_7 n3_7 0 dm
Rh3_7 n3_7 n3_8 100
Rv3_7 n3_7 n4_7 100
D3_8 n3_8 0 dm
Rh3_8 n3_8 n3_9 100
Rv3_8 n3_8 n4_8 100
D3_9 n3_9 0 dm
Rh3_9 n3_9 n3_10 100
Rv3_9 n3_9 n4_9 100
D3_10 n3_10 0 dm
Rh3_10 n3_10 n3_11 100
Rv3_10 n3_10 n4_10 100
D3_11 n3_11 0 dm
Rv3_11 n3_11 n4_11 100
D4_0 n4_0 0 dm
Rh4_0 n4_0 n4_1 100
Rv4_0 n4_0 n5_0 100
D4_1 n4_1 0 dm
Rh4_1 n4_1 n4_2 100
Rv4_1 n4_1 n5_1 100
D4_2 n4_2 0 dm
Rh4_2 n4_2 n4_3 100
Rv4_2 n4_2 n5_2 100
D4_3 n4_3 0 dm
Rh4_3 n4_3 n4_4 100
Rv4_3 n4_3 n5_3 100
D4_4 n4_4 0 dm
Rh4_4 n4_4 n4_5 100
Rv4_4 n4_4 n5_4 100
D4_5 n4_5 0 dm
Rh4_5 n4_5 n4_6 100
Rv4_5 n4_5 n5_5 100
D4_6 n4_6 0 dm
Rh4_6 n4_6 n4_7 100
Rv4_6 n4_6 n5_6 100
D4_7 n4_7 0 dm
Rh4_7 n4_7 n4_8 100
Rv4_7 n4_7 n5_7 100
D4_8 n4_8 0 dm
Rh4_8 n4_8 n4_9 100
Rv4_8 n4_8 n5_8 100
D4_9 n4_9 0 dm
Rh4_9 n4_9 n4_10 100
Rv4_9 n4_9 n5_9 100
D4_10 n4_10 0 dm
Rh4_10 n4_10 n4_11 100
Rv4_10 n4_10 n5_10 100
D4_11 n4_11 0 dm
Rv4_11 n4_11 n5_11 100
D5_0 n5_0 0 dm
Rh5_0 n5_0 n5_1 100
Rv5_0 n5_0 n6_0 100
D5_1 n5_1 0 dm
Rh5_1 n5_1 n5_2 100
Rv5_1 n5_1 n6_1 100
D5_2 n5_2 0 dm
Rh5_2 n5_2 n5_3 100
Rv5_2 n5_2 n6_2 100
D5_3 n5_3 0 dm
Rh5_3 n5_3 n5_4 100
Rv5_3 n5_3 n6_3 100
D5_4 n5_4 0 dm
Rh5_4 n5_4 n5_5 100
Rv5_4 n5_4 n6_4 100
D5_5 n5_5 0 dm
Rh5_5 n5_5 n5_6 100
Rv5_5 n5_5 n6_5 100
D5_6 n5_6 0 dm
Rh5_6 n5_6 n5_7 100
Rv5_6 n5_6 n6_6 100
D5_7 n5_7 0 dm
Rh5_7 n5_7 n5_8 100
Rv5_7 n5_7 n6_7 100
D5_8 n5_8 0 dm
Rh5_8 n5_8 n5_9 100
Rv5_8 n5_8 n6_8 100
D5_9 n5_9 0 dm
Rh5_9 n5_9 n5_10 100
Rv5_9 n5_9 n6_9 100
D5_10 n5_10 0 dm
Rh5_10 n5_10 n5_11 100
Rv5_10 n5_10 n6_10 100
D5_11 n5_11 0 dm
Rv5_11 n5_11 n6_11 100
D6_0 n6_0 0 dm
Rh6_0 n6_0 n6_1 100
Rv6_0 n6_0 n7_0 100
D6_1 n6_1 0 dm
Rh6_1 n6_1 n6_2 100
Rv6_1 n6_1 n7_1 100
D6_2 n6_2 0 dm
Rh6_2 n6_2 n6_3 100
Rv6_2 n6_2 n7_2 100
D6_3 n6_3 0 dm
Rh6_3 n6_3 n6_4 100
Rv6_3 n6_3 n7_3 100
D6_4 n6_4 0 dm
Rh6_4 n6_4 n6_5 100
Rv6_4 n6_4 n7_4 100
D6_5 n6_5 0 dm
Rh6_5 n6_5 n6_6 100
Rv6_5 n6_5 n7_5 100
D6_6 n6_6 0 dm
Rh6_6 n6_6 n6_7 100
Rv6_6 n6_6 n7_6 100
D6_7 n6_7 0 dm
Rh6_7 n6_7 n6_8 100
Rv6_7 n6_7 n7_7 100
D6_8 n6_8 0 dm
Rh6_8 n6_8 n6_9 100
Rv6_8 n6_8 n7_8 100
D6_9 n6_9 0 dm
Rh6_9 n6_9 n6_10 100
Rv6_9 n6_9 n7_9 100
D6_10 n6_10 0 dm
Rh6_10 n6_10 n6_11 100
Rv6_10 n6_10 n7_10 100
D6_11 n6_11 0 dm
Rv6_11 n6_11 n7_11 100
D7_0 n7_0 0 dm
Rh7_0 n7_0 n7_1 100
Rv7_0 n7_0 n8_0 100
D7_1 n7_1 0 dm
Rh7_1 n7_1 n7_2 100
Rv7_1 n7_1 n8_1 100
D7_2 n7_2 0 dm
Rh7_2 n7_2 n7_3 100
Rv7_2 n7_2 n8_2 100
D7_3 n7_3 0 dm
Rh7_3 n7_3 n7_4 100
Rv7_3 n7_3 n8_3 100
D7_4 n7_4 0 dm
Rh7_4 n7_4 n7_5 100
Rv7_4 n7_4 n8_4 100
D7_5 n7_5 0 dm
Rh7_5 n7_5 n7_6 100
Rv7_5 n7_5 n8_5 100
D7_6 n7_6 0 dm
Rh7_6 n7_6 n7_7 100
Rv7_6 n7_6 n8_6 100
D7_7 n7_7 0 dm
Rh7_7 n7_7 n7_8 100
Rv7_7 n7_7 n8_7 100
D7_8 n7_8 0 dm
Rh7_8 n7_8 n7_9 100
Rv7_8 n7_8 n8_8 100
D7_9 n7_9 0 dm
Rh7_9 n7_9 n7_10 100
Rv7_9 n7_9 n8_9 100
D7_10 n7_10 0 dm
Rh7_10 n7_10 n7_11 100
Rv7_10 n7_10 n8_10 100
D7_11 n7_11 0 dm
Rv7_11 n7_11 n8_11 100
D8_0 n8_0 0 dm
Rh8_0 n8_0 n8_1 100
Rv8_0 n8_0 n9_0 100
D8_1 n8_1 0 dm
Rh8_1 n8_1 n8_2 100
Rv8_1 n8_1 n9_1 100
D8_2 n8_2 0 dm
Rh8_2 n8_2 n8_3 100
Rv8_2 n8_2 n9_2 100
D8_3 n8_3 0 dm
Rh8_3 n8_3 n8_4 100
Rv8_3 n8_3 n9_3 100
D8_4 n8_4 0 dm
Rh8_4 n8_4 n8_5 100
Rv8_4 n8_4 n9_4 100
D8_5 n8_5 0 dm
Rh8_5 n8_5 n8_6 100
Rv8_5 n8_5 n9_5 100
D8_6 n8_6 0 dm
Rh8_6 n8_6 n8_7 100
Rv8_6 n8_6 n9_6 100
D8_7 n8_7 0 dm
Rh8_7 n8_7 n8_8 100
Rv8_7 n8_7 n9_7 100
D8_8 n8_8 0 dm
Rh8_8 n8_8 n8_9 100
Rv8_8 n8_8 n9_8 100
D8_9 n8_9 0 dm
Rh8_9 n8_9 n8_10 100
Rv8_9 n8_9 n9_9 100
D8_10 n8_10 0 dm
Rh8_10 n8_10 n8_11 100
Rv8_10 n8_10 n9_10 100
D8_11 n8_11 0 dm
Rv8_11 n8_11 n9_11 100
D9_0 n9_0 0 dm
Rh9_0 n9_0 n9_1 100
Rv9_0 n9_0 n10_0 100
D9_1 n9_1 0 dm
Rh9_1 n9_1 n9_2 100
Rv9_1 n9_1 n10_1 100
D9_2 n9_2 0 dm
Rh9_2 n9_2 n9_3 100
Rv9_2 n9_2 n10_2 100
D9_3 n9_3 0 dm
Rh9_3 n9_3 n9_4 100
Rv9_3 n9_3 n10_3 100
D9_4 n9_4 0 dm
Rh9_4 n9_4 n9_5 100
Rv9_4 n9_4 n10_4 100
D9_5 n9_5 0 dm
Rh9_5 n9_5 n9_6 100
Rv9_5 n9_5 n10_5 100
D9_6 n9_6 0 dm
Rh9_6 n9_6 n9_7 100
Rv9_6 n9_6 n10_6 100
D9_7 n9_7 0 dm
Rh9_7 n9_7 n9_8 100
Rv9_7 n9_7 n10_7 100
D9_8 n9_8 0 dm
Rh9_8 n9_8 n9_9 100
Rv9_8 n9_8 n10_8 100
D9_9 n9_9 0 dm
Rh9_9 n9_9 n9_10 100
Rv9_9 n9_9 n10_9 100
D9_10 n9_10 0 dm
Rh9_10 n9_10 n9_11 100
Rv9_10 n9_10 n10_10 100
D9_11 n9_11 0 dm
Rv9_11 n9_11 n10_11 100
D10_0 n10_0 0 dm
Rh10_0 n10_0 n10_1 100
Rv10_0 n10_0 n11_0 100
D10_1 n10_1 0 dm
Rh10_1 n10_1 n10_2 100
Rv10_1 n10_1 n11_1 100
D10_2 n10_2 0 dm
Rh10_2 n10_2 n10_3 100
Rv10_2 n10_2 n11_2 100
D10_3 n10_3 0 dm
Rh10_3 n10_3 n10_4 100
Rv10_3 n10_3 n11_3 100
D10_4 n10_4 0 dm
Rh10_4 n10_4 n10_5 100
Rv10_4 n10_4 n11_4 100
D10_5 n10_5 0 dm
Rh10_5 n10_5 n10_6 100
Rv10_5 n10_5 n11_5 100
D10_6 n10_6 0 dm
Rh10_6 n10_6 n10_7 100
Rv10_6 n10_6 n11_6 100
D10_7 n10_7 0 dm
Rh10_7 n10_7 n10_8 100
Rv10_7 n10_7 n11_7 100
D10_8 n10_8 0 dm
Rh10_8 n10_8 n10_9 100
Rv10_8 n10_8 n11_8 100
D10_9 n10_9 0 dm
Rh10_9 n10_9 n10_10 100
Rv10_9 n10_9 n11_9 100
D10_10 n10_10 0 dm
Rh10_10 n10_10 n10_11 100
Rv10_10 n10_10 n11_10 100
D10_11 n10_11 0 dm
Rv10_11 n10_11 n11_11 100
D11_0 n11_0 0 dm
Rh11_0 n11_0 n11_1 100
D11_1 n11_1 0 dm
Rh11_1 n11_1 n11_2 100
D11_2 n11_2 0 dm
Rh11_2 n11_2 n11_3 100
D11_3 n11_3 0 dm
Rh11_3 n11_3 n11_4 100
D11_4 n11_4 0 dm
Rh11_4 n11_4 n11_5 100
D11_5 n11_5 0 dm
Rh11_5 n11_5 n11_6 100
D11_6 n11_6 0 dm
Rh11_6 n11_6 n11_7 100
D11_7 n11_7 0 dm
Rh11_7 n11_7 n11_8 100
D11_8 n11_8 0 dm
Rh11_8 n11_8 n11_9 100
D11_9 n11_9 0 dm
Rh11_9 n11_9 n11_10 100
D11_10 n11_10 0 dm
Rh11_10 n11_10 n11_11 100
D11_11 n11_11 0 dm
.dc V1 0 3 0.05
.end
