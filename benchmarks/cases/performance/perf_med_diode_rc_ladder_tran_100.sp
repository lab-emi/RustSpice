RC line with 100 stages and a diode clamp at every node, pulse drive, 2000 steps
* bench.id: perf_med_diode_rc_ladder_tran_100
* bench.group: performance
* bench.title: RC line with 100 stages and a diode clamp at every node, pulse drive, 2000 steps
* bench.probes: v(n1), v(n50), v(n100), i(v1)
* bench.tol.norm: 5e-3
* bench.expect: match
* bench.ref: reltol=1e-6 abstol=1e-15 vntol=1e-9
* bench.ref.tmax: 0.2n
* bench.ng.solver: both
* bench.timing: yes
* bench.size: 103
* bench.est_rss_mib: 15
* bench.tags: nonlinear, tran, ladder, diode, medium
* bench.note: lossy line with 100 conducting clamp diodes: every step is a Newton solve of a 103-unknown banded system
.model dm D(IS=1e-14 N=1)
V1 s 0 PULSE(0 3 1n 20n 20n 150n 400n)
Rs s n0 200
R1 n0 n1 100
C1 n1 0 1p
D1 n1 0 dm
R2 n1 n2 100
C2 n2 0 1p
D2 n2 0 dm
R3 n2 n3 100
C3 n3 0 1p
D3 n3 0 dm
R4 n3 n4 100
C4 n4 0 1p
D4 n4 0 dm
R5 n4 n5 100
C5 n5 0 1p
D5 n5 0 dm
R6 n5 n6 100
C6 n6 0 1p
D6 n6 0 dm
R7 n6 n7 100
C7 n7 0 1p
D7 n7 0 dm
R8 n7 n8 100
C8 n8 0 1p
D8 n8 0 dm
R9 n8 n9 100
C9 n9 0 1p
D9 n9 0 dm
R10 n9 n10 100
C10 n10 0 1p
D10 n10 0 dm
R11 n10 n11 100
C11 n11 0 1p
D11 n11 0 dm
R12 n11 n12 100
C12 n12 0 1p
D12 n12 0 dm
R13 n12 n13 100
C13 n13 0 1p
D13 n13 0 dm
R14 n13 n14 100
C14 n14 0 1p
D14 n14 0 dm
R15 n14 n15 100
C15 n15 0 1p
D15 n15 0 dm
R16 n15 n16 100
C16 n16 0 1p
D16 n16 0 dm
R17 n16 n17 100
C17 n17 0 1p
D17 n17 0 dm
R18 n17 n18 100
C18 n18 0 1p
D18 n18 0 dm
R19 n18 n19 100
C19 n19 0 1p
D19 n19 0 dm
R20 n19 n20 100
C20 n20 0 1p
D20 n20 0 dm
R21 n20 n21 100
C21 n21 0 1p
D21 n21 0 dm
R22 n21 n22 100
C22 n22 0 1p
D22 n22 0 dm
R23 n22 n23 100
C23 n23 0 1p
D23 n23 0 dm
R24 n23 n24 100
C24 n24 0 1p
D24 n24 0 dm
R25 n24 n25 100
C25 n25 0 1p
D25 n25 0 dm
R26 n25 n26 100
C26 n26 0 1p
D26 n26 0 dm
R27 n26 n27 100
C27 n27 0 1p
D27 n27 0 dm
R28 n27 n28 100
C28 n28 0 1p
D28 n28 0 dm
R29 n28 n29 100
C29 n29 0 1p
D29 n29 0 dm
R30 n29 n30 100
C30 n30 0 1p
D30 n30 0 dm
R31 n30 n31 100
C31 n31 0 1p
D31 n31 0 dm
R32 n31 n32 100
C32 n32 0 1p
D32 n32 0 dm
R33 n32 n33 100
C33 n33 0 1p
D33 n33 0 dm
R34 n33 n34 100
C34 n34 0 1p
D34 n34 0 dm
R35 n34 n35 100
C35 n35 0 1p
D35 n35 0 dm
R36 n35 n36 100
C36 n36 0 1p
D36 n36 0 dm
R37 n36 n37 100
C37 n37 0 1p
D37 n37 0 dm
R38 n37 n38 100
C38 n38 0 1p
D38 n38 0 dm
R39 n38 n39 100
C39 n39 0 1p
D39 n39 0 dm
R40 n39 n40 100
C40 n40 0 1p
D40 n40 0 dm
R41 n40 n41 100
C41 n41 0 1p
D41 n41 0 dm
R42 n41 n42 100
C42 n42 0 1p
D42 n42 0 dm
R43 n42 n43 100
C43 n43 0 1p
D43 n43 0 dm
R44 n43 n44 100
C44 n44 0 1p
D44 n44 0 dm
R45 n44 n45 100
C45 n45 0 1p
D45 n45 0 dm
R46 n45 n46 100
C46 n46 0 1p
D46 n46 0 dm
R47 n46 n47 100
C47 n47 0 1p
D47 n47 0 dm
R48 n47 n48 100
C48 n48 0 1p
D48 n48 0 dm
R49 n48 n49 100
C49 n49 0 1p
D49 n49 0 dm
R50 n49 n50 100
C50 n50 0 1p
D50 n50 0 dm
R51 n50 n51 100
C51 n51 0 1p
D51 n51 0 dm
R52 n51 n52 100
C52 n52 0 1p
D52 n52 0 dm
R53 n52 n53 100
C53 n53 0 1p
D53 n53 0 dm
R54 n53 n54 100
C54 n54 0 1p
D54 n54 0 dm
R55 n54 n55 100
C55 n55 0 1p
D55 n55 0 dm
R56 n55 n56 100
C56 n56 0 1p
D56 n56 0 dm
R57 n56 n57 100
C57 n57 0 1p
D57 n57 0 dm
R58 n57 n58 100
C58 n58 0 1p
D58 n58 0 dm
R59 n58 n59 100
C59 n59 0 1p
D59 n59 0 dm
R60 n59 n60 100
C60 n60 0 1p
D60 n60 0 dm
R61 n60 n61 100
C61 n61 0 1p
D61 n61 0 dm
R62 n61 n62 100
C62 n62 0 1p
D62 n62 0 dm
R63 n62 n63 100
C63 n63 0 1p
D63 n63 0 dm
R64 n63 n64 100
C64 n64 0 1p
D64 n64 0 dm
R65 n64 n65 100
C65 n65 0 1p
D65 n65 0 dm
R66 n65 n66 100
C66 n66 0 1p
D66 n66 0 dm
R67 n66 n67 100
C67 n67 0 1p
D67 n67 0 dm
R68 n67 n68 100
C68 n68 0 1p
D68 n68 0 dm
R69 n68 n69 100
C69 n69 0 1p
D69 n69 0 dm
R70 n69 n70 100
C70 n70 0 1p
D70 n70 0 dm
R71 n70 n71 100
C71 n71 0 1p
D71 n71 0 dm
R72 n71 n72 100
C72 n72 0 1p
D72 n72 0 dm
R73 n72 n73 100
C73 n73 0 1p
D73 n73 0 dm
R74 n73 n74 100
C74 n74 0 1p
D74 n74 0 dm
R75 n74 n75 100
C75 n75 0 1p
D75 n75 0 dm
R76 n75 n76 100
C76 n76 0 1p
D76 n76 0 dm
R77 n76 n77 100
C77 n77 0 1p
D77 n77 0 dm
R78 n77 n78 100
C78 n78 0 1p
D78 n78 0 dm
R79 n78 n79 100
C79 n79 0 1p
D79 n79 0 dm
R80 n79 n80 100
C80 n80 0 1p
D80 n80 0 dm
R81 n80 n81 100
C81 n81 0 1p
D81 n81 0 dm
R82 n81 n82 100
C82 n82 0 1p
D82 n82 0 dm
R83 n82 n83 100
C83 n83 0 1p
D83 n83 0 dm
R84 n83 n84 100
C84 n84 0 1p
D84 n84 0 dm
R85 n84 n85 100
C85 n85 0 1p
D85 n85 0 dm
R86 n85 n86 100
C86 n86 0 1p
D86 n86 0 dm
R87 n86 n87 100
C87 n87 0 1p
D87 n87 0 dm
R88 n87 n88 100
C88 n88 0 1p
D88 n88 0 dm
R89 n88 n89 100
C89 n89 0 1p
D89 n89 0 dm
R90 n89 n90 100
C90 n90 0 1p
D90 n90 0 dm
R91 n90 n91 100
C91 n91 0 1p
D91 n91 0 dm
R92 n91 n92 100
C92 n92 0 1p
D92 n92 0 dm
R93 n92 n93 100
C93 n93 0 1p
D93 n93 0 dm
R94 n93 n94 100
C94 n94 0 1p
D94 n94 0 dm
R95 n94 n95 100
C95 n95 0 1p
D95 n95 0 dm
R96 n95 n96 100
C96 n96 0 1p
D96 n96 0 dm
R97 n96 n97 100
C97 n97 0 1p
D97 n97 0 dm
R98 n97 n98 100
C98 n98 0 1p
D98 n98 0 dm
R99 n98 n99 100
C99 n99 0 1p
D99 n99 0 dm
R100 n99 n100 100
C100 n100 0 1p
D100 n100 0 dm
.tran 0.2n 400n
.end
