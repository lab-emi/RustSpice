Resistor ladder with 200 stages and a diode-resistor shunt per node, one operating point
* bench.id: perf_med_diode_ladder_op_200
* bench.group: performance
* bench.title: Resistor ladder with 200 stages and a diode-resistor shunt per node, one operating point
* bench.probes: v(n1), v(n100), v(n200), i(v1)
* bench.tol.rel: 1e-6
* bench.tol.abs: 1e-9
* bench.expect: match
* bench.oracle: dc_nonlinear
* bench.ng.solver: both
* bench.timing: yes
* bench.size: 402
* bench.est_rss_mib: 10
* bench.tags: nonlinear, op, ladder, diode, medium
* bench.note: 1-D nonlinear line of 402 unknowns (banded Jacobian): every node adds a diode-resistor shunt, so the supply droops along the line
.model dm D(IS=1e-14 N=1)
V1 n0 0 1.2
R1 n0 n1 10
Rd1 n1 m1 5k
D1 m1 0 dm
R2 n1 n2 10
Rd2 n2 m2 5k
D2 m2 0 dm
R3 n2 n3 10
Rd3 n3 m3 5k
D3 m3 0 dm
R4 n3 n4 10
Rd4 n4 m4 5k
D4 m4 0 dm
R5 n4 n5 10
Rd5 n5 m5 5k
D5 m5 0 dm
R6 n5 n6 10
Rd6 n6 m6 5k
D6 m6 0 dm
R7 n6 n7 10
Rd7 n7 m7 5k
D7 m7 0 dm
R8 n7 n8 10
Rd8 n8 m8 5k
D8 m8 0 dm
R9 n8 n9 10
Rd9 n9 m9 5k
D9 m9 0 dm
R10 n9 n10 10
Rd10 n10 m10 5k
D10 m10 0 dm
R11 n10 n11 10
Rd11 n11 m11 5k
D11 m11 0 dm
R12 n11 n12 10
Rd12 n12 m12 5k
D12 m12 0 dm
R13 n12 n13 10
Rd13 n13 m13 5k
D13 m13 0 dm
R14 n13 n14 10
Rd14 n14 m14 5k
D14 m14 0 dm
R15 n14 n15 10
Rd15 n15 m15 5k
D15 m15 0 dm
R16 n15 n16 10
Rd16 n16 m16 5k
D16 m16 0 dm
R17 n16 n17 10
Rd17 n17 m17 5k
D17 m17 0 dm
R18 n17 n18 10
Rd18 n18 m18 5k
D18 m18 0 dm
R19 n18 n19 10
Rd19 n19 m19 5k
D19 m19 0 dm
R20 n19 n20 10
Rd20 n20 m20 5k
D20 m20 0 dm
R21 n20 n21 10
Rd21 n21 m21 5k
D21 m21 0 dm
R22 n21 n22 10
Rd22 n22 m22 5k
D22 m22 0 dm
R23 n22 n23 10
Rd23 n23 m23 5k
D23 m23 0 dm
R24 n23 n24 10
Rd24 n24 m24 5k
D24 m24 0 dm
R25 n24 n25 10
Rd25 n25 m25 5k
D25 m25 0 dm
R26 n25 n26 10
Rd26 n26 m26 5k
D26 m26 0 dm
R27 n26 n27 10
Rd27 n27 m27 5k
D27 m27 0 dm
R28 n27 n28 10
Rd28 n28 m28 5k
D28 m28 0 dm
R29 n28 n29 10
Rd29 n29 m29 5k
D29 m29 0 dm
R30 n29 n30 10
Rd30 n30 m30 5k
D30 m30 0 dm
R31 n30 n31 10
Rd31 n31 m31 5k
D31 m31 0 dm
R32 n31 n32 10
Rd32 n32 m32 5k
D32 m32 0 dm
R33 n32 n33 10
Rd33 n33 m33 5k
D33 m33 0 dm
R34 n33 n34 10
Rd34 n34 m34 5k
D34 m34 0 dm
R35 n34 n35 10
Rd35 n35 m35 5k
D35 m35 0 dm
R36 n35 n36 10
Rd36 n36 m36 5k
D36 m36 0 dm
R37 n36 n37 10
Rd37 n37 m37 5k
D37 m37 0 dm
R38 n37 n38 10
Rd38 n38 m38 5k
D38 m38 0 dm
R39 n38 n39 10
Rd39 n39 m39 5k
D39 m39 0 dm
R40 n39 n40 10
Rd40 n40 m40 5k
D40 m40 0 dm
R41 n40 n41 10
Rd41 n41 m41 5k
D41 m41 0 dm
R42 n41 n42 10
Rd42 n42 m42 5k
D42 m42 0 dm
R43 n42 n43 10
Rd43 n43 m43 5k
D43 m43 0 dm
R44 n43 n44 10
Rd44 n44 m44 5k
D44 m44 0 dm
R45 n44 n45 10
Rd45 n45 m45 5k
D45 m45 0 dm
R46 n45 n46 10
Rd46 n46 m46 5k
D46 m46 0 dm
R47 n46 n47 10
Rd47 n47 m47 5k
D47 m47 0 dm
R48 n47 n48 10
Rd48 n48 m48 5k
D48 m48 0 dm
R49 n48 n49 10
Rd49 n49 m49 5k
D49 m49 0 dm
R50 n49 n50 10
Rd50 n50 m50 5k
D50 m50 0 dm
R51 n50 n51 10
Rd51 n51 m51 5k
D51 m51 0 dm
R52 n51 n52 10
Rd52 n52 m52 5k
D52 m52 0 dm
R53 n52 n53 10
Rd53 n53 m53 5k
D53 m53 0 dm
R54 n53 n54 10
Rd54 n54 m54 5k
D54 m54 0 dm
R55 n54 n55 10
Rd55 n55 m55 5k
D55 m55 0 dm
R56 n55 n56 10
Rd56 n56 m56 5k
D56 m56 0 dm
R57 n56 n57 10
Rd57 n57 m57 5k
D57 m57 0 dm
R58 n57 n58 10
Rd58 n58 m58 5k
D58 m58 0 dm
R59 n58 n59 10
Rd59 n59 m59 5k
D59 m59 0 dm
R60 n59 n60 10
Rd60 n60 m60 5k
D60 m60 0 dm
R61 n60 n61 10
Rd61 n61 m61 5k
D61 m61 0 dm
R62 n61 n62 10
Rd62 n62 m62 5k
D62 m62 0 dm
R63 n62 n63 10
Rd63 n63 m63 5k
D63 m63 0 dm
R64 n63 n64 10
Rd64 n64 m64 5k
D64 m64 0 dm
R65 n64 n65 10
Rd65 n65 m65 5k
D65 m65 0 dm
R66 n65 n66 10
Rd66 n66 m66 5k
D66 m66 0 dm
R67 n66 n67 10
Rd67 n67 m67 5k
D67 m67 0 dm
R68 n67 n68 10
Rd68 n68 m68 5k
D68 m68 0 dm
R69 n68 n69 10
Rd69 n69 m69 5k
D69 m69 0 dm
R70 n69 n70 10
Rd70 n70 m70 5k
D70 m70 0 dm
R71 n70 n71 10
Rd71 n71 m71 5k
D71 m71 0 dm
R72 n71 n72 10
Rd72 n72 m72 5k
D72 m72 0 dm
R73 n72 n73 10
Rd73 n73 m73 5k
D73 m73 0 dm
R74 n73 n74 10
Rd74 n74 m74 5k
D74 m74 0 dm
R75 n74 n75 10
Rd75 n75 m75 5k
D75 m75 0 dm
R76 n75 n76 10
Rd76 n76 m76 5k
D76 m76 0 dm
R77 n76 n77 10
Rd77 n77 m77 5k
D77 m77 0 dm
R78 n77 n78 10
Rd78 n78 m78 5k
D78 m78 0 dm
R79 n78 n79 10
Rd79 n79 m79 5k
D79 m79 0 dm
R80 n79 n80 10
Rd80 n80 m80 5k
D80 m80 0 dm
R81 n80 n81 10
Rd81 n81 m81 5k
D81 m81 0 dm
R82 n81 n82 10
Rd82 n82 m82 5k
D82 m82 0 dm
R83 n82 n83 10
Rd83 n83 m83 5k
D83 m83 0 dm
R84 n83 n84 10
Rd84 n84 m84 5k
D84 m84 0 dm
R85 n84 n85 10
Rd85 n85 m85 5k
D85 m85 0 dm
R86 n85 n86 10
Rd86 n86 m86 5k
D86 m86 0 dm
R87 n86 n87 10
Rd87 n87 m87 5k
D87 m87 0 dm
R88 n87 n88 10
Rd88 n88 m88 5k
D88 m88 0 dm
R89 n88 n89 10
Rd89 n89 m89 5k
D89 m89 0 dm
R90 n89 n90 10
Rd90 n90 m90 5k
D90 m90 0 dm
R91 n90 n91 10
Rd91 n91 m91 5k
D91 m91 0 dm
R92 n91 n92 10
Rd92 n92 m92 5k
D92 m92 0 dm
R93 n92 n93 10
Rd93 n93 m93 5k
D93 m93 0 dm
R94 n93 n94 10
Rd94 n94 m94 5k
D94 m94 0 dm
R95 n94 n95 10
Rd95 n95 m95 5k
D95 m95 0 dm
R96 n95 n96 10
Rd96 n96 m96 5k
D96 m96 0 dm
R97 n96 n97 10
Rd97 n97 m97 5k
D97 m97 0 dm
R98 n97 n98 10
Rd98 n98 m98 5k
D98 m98 0 dm
R99 n98 n99 10
Rd99 n99 m99 5k
D99 m99 0 dm
R100 n99 n100 10
Rd100 n100 m100 5k
D100 m100 0 dm
R101 n100 n101 10
Rd101 n101 m101 5k
D101 m101 0 dm
R102 n101 n102 10
Rd102 n102 m102 5k
D102 m102 0 dm
R103 n102 n103 10
Rd103 n103 m103 5k
D103 m103 0 dm
R104 n103 n104 10
Rd104 n104 m104 5k
D104 m104 0 dm
R105 n104 n105 10
Rd105 n105 m105 5k
D105 m105 0 dm
R106 n105 n106 10
Rd106 n106 m106 5k
D106 m106 0 dm
R107 n106 n107 10
Rd107 n107 m107 5k
D107 m107 0 dm
R108 n107 n108 10
Rd108 n108 m108 5k
D108 m108 0 dm
R109 n108 n109 10
Rd109 n109 m109 5k
D109 m109 0 dm
R110 n109 n110 10
Rd110 n110 m110 5k
D110 m110 0 dm
R111 n110 n111 10
Rd111 n111 m111 5k
D111 m111 0 dm
R112 n111 n112 10
Rd112 n112 m112 5k
D112 m112 0 dm
R113 n112 n113 10
Rd113 n113 m113 5k
D113 m113 0 dm
R114 n113 n114 10
Rd114 n114 m114 5k
D114 m114 0 dm
R115 n114 n115 10
Rd115 n115 m115 5k
D115 m115 0 dm
R116 n115 n116 10
Rd116 n116 m116 5k
D116 m116 0 dm
R117 n116 n117 10
Rd117 n117 m117 5k
D117 m117 0 dm
R118 n117 n118 10
Rd118 n118 m118 5k
D118 m118 0 dm
R119 n118 n119 10
Rd119 n119 m119 5k
D119 m119 0 dm
R120 n119 n120 10
Rd120 n120 m120 5k
D120 m120 0 dm
R121 n120 n121 10
Rd121 n121 m121 5k
D121 m121 0 dm
R122 n121 n122 10
Rd122 n122 m122 5k
D122 m122 0 dm
R123 n122 n123 10
Rd123 n123 m123 5k
D123 m123 0 dm
R124 n123 n124 10
Rd124 n124 m124 5k
D124 m124 0 dm
R125 n124 n125 10
Rd125 n125 m125 5k
D125 m125 0 dm
R126 n125 n126 10
Rd126 n126 m126 5k
D126 m126 0 dm
R127 n126 n127 10
Rd127 n127 m127 5k
D127 m127 0 dm
R128 n127 n128 10
Rd128 n128 m128 5k
D128 m128 0 dm
R129 n128 n129 10
Rd129 n129 m129 5k
D129 m129 0 dm
R130 n129 n130 10
Rd130 n130 m130 5k
D130 m130 0 dm
R131 n130 n131 10
Rd131 n131 m131 5k
D131 m131 0 dm
R132 n131 n132 10
Rd132 n132 m132 5k
D132 m132 0 dm
R133 n132 n133 10
Rd133 n133 m133 5k
D133 m133 0 dm
R134 n133 n134 10
Rd134 n134 m134 5k
D134 m134 0 dm
R135 n134 n135 10
Rd135 n135 m135 5k
D135 m135 0 dm
R136 n135 n136 10
Rd136 n136 m136 5k
D136 m136 0 dm
R137 n136 n137 10
Rd137 n137 m137 5k
D137 m137 0 dm
R138 n137 n138 10
Rd138 n138 m138 5k
D138 m138 0 dm
R139 n138 n139 10
Rd139 n139 m139 5k
D139 m139 0 dm
R140 n139 n140 10
Rd140 n140 m140 5k
D140 m140 0 dm
R141 n140 n141 10
Rd141 n141 m141 5k
D141 m141 0 dm
R142 n141 n142 10
Rd142 n142 m142 5k
D142 m142 0 dm
R143 n142 n143 10
Rd143 n143 m143 5k
D143 m143 0 dm
R144 n143 n144 10
Rd144 n144 m144 5k
D144 m144 0 dm
R145 n144 n145 10
Rd145 n145 m145 5k
D145 m145 0 dm
R146 n145 n146 10
Rd146 n146 m146 5k
D146 m146 0 dm
R147 n146 n147 10
Rd147 n147 m147 5k
D147 m147 0 dm
R148 n147 n148 10
Rd148 n148 m148 5k
D148 m148 0 dm
R149 n148 n149 10
Rd149 n149 m149 5k
D149 m149 0 dm
R150 n149 n150 10
Rd150 n150 m150 5k
D150 m150 0 dm
R151 n150 n151 10
Rd151 n151 m151 5k
D151 m151 0 dm
R152 n151 n152 10
Rd152 n152 m152 5k
D152 m152 0 dm
R153 n152 n153 10
Rd153 n153 m153 5k
D153 m153 0 dm
R154 n153 n154 10
Rd154 n154 m154 5k
D154 m154 0 dm
R155 n154 n155 10
Rd155 n155 m155 5k
D155 m155 0 dm
R156 n155 n156 10
Rd156 n156 m156 5k
D156 m156 0 dm
R157 n156 n157 10
Rd157 n157 m157 5k
D157 m157 0 dm
R158 n157 n158 10
Rd158 n158 m158 5k
D158 m158 0 dm
R159 n158 n159 10
Rd159 n159 m159 5k
D159 m159 0 dm
R160 n159 n160 10
Rd160 n160 m160 5k
D160 m160 0 dm
R161 n160 n161 10
Rd161 n161 m161 5k
D161 m161 0 dm
R162 n161 n162 10
Rd162 n162 m162 5k
D162 m162 0 dm
R163 n162 n163 10
Rd163 n163 m163 5k
D163 m163 0 dm
R164 n163 n164 10
Rd164 n164 m164 5k
D164 m164 0 dm
R165 n164 n165 10
Rd165 n165 m165 5k
D165 m165 0 dm
R166 n165 n166 10
Rd166 n166 m166 5k
D166 m166 0 dm
R167 n166 n167 10
Rd167 n167 m167 5k
D167 m167 0 dm
R168 n167 n168 10
Rd168 n168 m168 5k
D168 m168 0 dm
R169 n168 n169 10
Rd169 n169 m169 5k
D169 m169 0 dm
R170 n169 n170 10
Rd170 n170 m170 5k
D170 m170 0 dm
R171 n170 n171 10
Rd171 n171 m171 5k
D171 m171 0 dm
R172 n171 n172 10
Rd172 n172 m172 5k
D172 m172 0 dm
R173 n172 n173 10
Rd173 n173 m173 5k
D173 m173 0 dm
R174 n173 n174 10
Rd174 n174 m174 5k
D174 m174 0 dm
R175 n174 n175 10
Rd175 n175 m175 5k
D175 m175 0 dm
R176 n175 n176 10
Rd176 n176 m176 5k
D176 m176 0 dm
R177 n176 n177 10
Rd177 n177 m177 5k
D177 m177 0 dm
R178 n177 n178 10
Rd178 n178 m178 5k
D178 m178 0 dm
R179 n178 n179 10
Rd179 n179 m179 5k
D179 m179 0 dm
R180 n179 n180 10
Rd180 n180 m180 5k
D180 m180 0 dm
R181 n180 n181 10
Rd181 n181 m181 5k
D181 m181 0 dm
R182 n181 n182 10
Rd182 n182 m182 5k
D182 m182 0 dm
R183 n182 n183 10
Rd183 n183 m183 5k
D183 m183 0 dm
R184 n183 n184 10
Rd184 n184 m184 5k
D184 m184 0 dm
R185 n184 n185 10
Rd185 n185 m185 5k
D185 m185 0 dm
R186 n185 n186 10
Rd186 n186 m186 5k
D186 m186 0 dm
R187 n186 n187 10
Rd187 n187 m187 5k
D187 m187 0 dm
R188 n187 n188 10
Rd188 n188 m188 5k
D188 m188 0 dm
R189 n188 n189 10
Rd189 n189 m189 5k
D189 m189 0 dm
R190 n189 n190 10
Rd190 n190 m190 5k
D190 m190 0 dm
R191 n190 n191 10
Rd191 n191 m191 5k
D191 m191 0 dm
R192 n191 n192 10
Rd192 n192 m192 5k
D192 m192 0 dm
R193 n192 n193 10
Rd193 n193 m193 5k
D193 m193 0 dm
R194 n193 n194 10
Rd194 n194 m194 5k
D194 m194 0 dm
R195 n194 n195 10
Rd195 n195 m195 5k
D195 m195 0 dm
R196 n195 n196 10
Rd196 n196 m196 5k
D196 m196 0 dm
R197 n196 n197 10
Rd197 n197 m197 5k
D197 m197 0 dm
R198 n197 n198 10
Rd198 n198 m198 5k
D198 m198 0 dm
R199 n198 n199 10
Rd199 n199 m199 5k
D199 m199 0 dm
R200 n199 n200 10
Rd200 n200 m200 5k
D200 m200 0 dm
.op
.end
