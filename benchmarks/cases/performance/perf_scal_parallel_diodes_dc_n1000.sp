1000 identical diodes in parallel behind 100 ohm, 51-point source sweep
* bench.id: perf_scal_parallel_diodes_dc_n1000
* bench.group: performance
* bench.title: 1000 identical diodes in parallel behind 100 ohm, 51-point source sweep
* bench.probes: v(a), i(v1)
* bench.tol.rel: 1e-6
* bench.tol.abs: 1e-9
* bench.expect: match
* bench.oracle: dc_nonlinear
* bench.ng.solver: both
* bench.timing: yes
* bench.size: 1000
* bench.est_rss_mib: 29
* bench.tags: nonlinear, dc, sweep, diode, jit_tier, devcount, family:perf_scal_parallel_diodes_dc
* bench.note: N=1e3 identical diodes between node a and ground behind 100 ohm: a 3-unknown matrix (v(in), v(a), i(v1)), so the cost is the per-device kernels only; exact solution from a 60-digit mpmath bisection of (V-v)/R = N*(IS*(exp(v/Vt)-1)+gmin*v) agrees with rustspice to 2.5e-12 V and 2.5e-14 A at all 51 points, while ngspice at default tolerances is 1.7e-4 V off (hence the tight reference); step 2^-4 V keeps the sweep grid exact; scaling family perf_scal_parallel_diodes_dc (size = diode count); measured on an idle core (median of 5): rustspice e2e 10.3 ms vs ngspice SPARSE 20.4 ms and KLU 20.4 ms
.model dm D(IS=1e-14 N=1)
V1 in 0 0
R1 in a 100
D1 a 0 dm
D2 a 0 dm
D3 a 0 dm
D4 a 0 dm
D5 a 0 dm
D6 a 0 dm
D7 a 0 dm
D8 a 0 dm
D9 a 0 dm
D10 a 0 dm
D11 a 0 dm
D12 a 0 dm
D13 a 0 dm
D14 a 0 dm
D15 a 0 dm
D16 a 0 dm
D17 a 0 dm
D18 a 0 dm
D19 a 0 dm
D20 a 0 dm
D21 a 0 dm
D22 a 0 dm
D23 a 0 dm
D24 a 0 dm
D25 a 0 dm
D26 a 0 dm
D27 a 0 dm
D28 a 0 dm
D29 a 0 dm
D30 a 0 dm
D31 a 0 dm
D32 a 0 dm
D33 a 0 dm
D34 a 0 dm
D35 a 0 dm
D36 a 0 dm
D37 a 0 dm
D38 a 0 dm
D39 a 0 dm
D40 a 0 dm
D41 a 0 dm
D42 a 0 dm
D43 a 0 dm
D44 a 0 dm
D45 a 0 dm
D46 a 0 dm
D47 a 0 dm
D48 a 0 dm
D49 a 0 dm
D50 a 0 dm
D51 a 0 dm
D52 a 0 dm
D53 a 0 dm
D54 a 0 dm
D55 a 0 dm
D56 a 0 dm
D57 a 0 dm
D58 a 0 dm
D59 a 0 dm
D60 a 0 dm
D61 a 0 dm
D62 a 0 dm
D63 a 0 dm
D64 a 0 dm
D65 a 0 dm
D66 a 0 dm
D67 a 0 dm
D68 a 0 dm
D69 a 0 dm
D70 a 0 dm
D71 a 0 dm
D72 a 0 dm
D73 a 0 dm
D74 a 0 dm
D75 a 0 dm
D76 a 0 dm
D77 a 0 dm
D78 a 0 dm
D79 a 0 dm
D80 a 0 dm
D81 a 0 dm
D82 a 0 dm
D83 a 0 dm
D84 a 0 dm
D85 a 0 dm
D86 a 0 dm
D87 a 0 dm
D88 a 0 dm
D89 a 0 dm
D90 a 0 dm
D91 a 0 dm
D92 a 0 dm
D93 a 0 dm
D94 a 0 dm
D95 a 0 dm
D96 a 0 dm
D97 a 0 dm
D98 a 0 dm
D99 a 0 dm
D100 a 0 dm
D101 a 0 dm
D102 a 0 dm
D103 a 0 dm
D104 a 0 dm
D105 a 0 dm
D106 a 0 dm
D107 a 0 dm
D108 a 0 dm
D109 a 0 dm
D110 a 0 dm
D111 a 0 dm
D112 a 0 dm
D113 a 0 dm
D114 a 0 dm
D115 a 0 dm
D116 a 0 dm
D117 a 0 dm
D118 a 0 dm
D119 a 0 dm
D120 a 0 dm
D121 a 0 dm
D122 a 0 dm
D123 a 0 dm
D124 a 0 dm
D125 a 0 dm
D126 a 0 dm
D127 a 0 dm
D128 a 0 dm
D129 a 0 dm
D130 a 0 dm
D131 a 0 dm
D132 a 0 dm
D133 a 0 dm
D134 a 0 dm
D135 a 0 dm
D136 a 0 dm
D137 a 0 dm
D138 a 0 dm
D139 a 0 dm
D140 a 0 dm
D141 a 0 dm
D142 a 0 dm
D143 a 0 dm
D144 a 0 dm
D145 a 0 dm
D146 a 0 dm
D147 a 0 dm
D148 a 0 dm
D149 a 0 dm
D150 a 0 dm
D151 a 0 dm
D152 a 0 dm
D153 a 0 dm
D154 a 0 dm
D155 a 0 dm
D156 a 0 dm
D157 a 0 dm
D158 a 0 dm
D159 a 0 dm
D160 a 0 dm
D161 a 0 dm
D162 a 0 dm
D163 a 0 dm
D164 a 0 dm
D165 a 0 dm
D166 a 0 dm
D167 a 0 dm
D168 a 0 dm
D169 a 0 dm
D170 a 0 dm
D171 a 0 dm
D172 a 0 dm
D173 a 0 dm
D174 a 0 dm
D175 a 0 dm
D176 a 0 dm
D177 a 0 dm
D178 a 0 dm
D179 a 0 dm
D180 a 0 dm
D181 a 0 dm
D182 a 0 dm
D183 a 0 dm
D184 a 0 dm
D185 a 0 dm
D186 a 0 dm
D187 a 0 dm
D188 a 0 dm
D189 a 0 dm
D190 a 0 dm
D191 a 0 dm
D192 a 0 dm
D193 a 0 dm
D194 a 0 dm
D195 a 0 dm
D196 a 0 dm
D197 a 0 dm
D198 a 0 dm
D199 a 0 dm
D200 a 0 dm
D201 a 0 dm
D202 a 0 dm
D203 a 0 dm
D204 a 0 dm
D205 a 0 dm
D206 a 0 dm
D207 a 0 dm
D208 a 0 dm
D209 a 0 dm
D210 a 0 dm
D211 a 0 dm
D212 a 0 dm
D213 a 0 dm
D214 a 0 dm
D215 a 0 dm
D216 a 0 dm
D217 a 0 dm
D218 a 0 dm
D219 a 0 dm
D220 a 0 dm
D221 a 0 dm
D222 a 0 dm
D223 a 0 dm
D224 a 0 dm
D225 a 0 dm
D226 a 0 dm
D227 a 0 dm
D228 a 0 dm
D229 a 0 dm
D230 a 0 dm
D231 a 0 dm
D232 a 0 dm
D233 a 0 dm
D234 a 0 dm
D235 a 0 dm
D236 a 0 dm
D237 a 0 dm
D238 a 0 dm
D239 a 0 dm
D240 a 0 dm
D241 a 0 dm
D242 a 0 dm
D243 a 0 dm
D244 a 0 dm
D245 a 0 dm
D246 a 0 dm
D247 a 0 dm
D248 a 0 dm
D249 a 0 dm
D250 a 0 dm
D251 a 0 dm
D252 a 0 dm
D253 a 0 dm
D254 a 0 dm
D255 a 0 dm
D256 a 0 dm
D257 a 0 dm
D258 a 0 dm
D259 a 0 dm
D260 a 0 dm
D261 a 0 dm
D262 a 0 dm
D263 a 0 dm
D264 a 0 dm
D265 a 0 dm
D266 a 0 dm
D267 a 0 dm
D268 a 0 dm
D269 a 0 dm
D270 a 0 dm
D271 a 0 dm
D272 a 0 dm
D273 a 0 dm
D274 a 0 dm
D275 a 0 dm
D276 a 0 dm
D277 a 0 dm
D278 a 0 dm
D279 a 0 dm
D280 a 0 dm
D281 a 0 dm
D282 a 0 dm
D283 a 0 dm
D284 a 0 dm
D285 a 0 dm
D286 a 0 dm
D287 a 0 dm
D288 a 0 dm
D289 a 0 dm
D290 a 0 dm
D291 a 0 dm
D292 a 0 dm
D293 a 0 dm
D294 a 0 dm
D295 a 0 dm
D296 a 0 dm
D297 a 0 dm
D298 a 0 dm
D299 a 0 dm
D300 a 0 dm
D301 a 0 dm
D302 a 0 dm
D303 a 0 dm
D304 a 0 dm
D305 a 0 dm
D306 a 0 dm
D307 a 0 dm
D308 a 0 dm
D309 a 0 dm
D310 a 0 dm
D311 a 0 dm
D312 a 0 dm
D313 a 0 dm
D314 a 0 dm
D315 a 0 dm
D316 a 0 dm
D317 a 0 dm
D318 a 0 dm
D319 a 0 dm
D320 a 0 dm
D321 a 0 dm
D322 a 0 dm
D323 a 0 dm
D324 a 0 dm
D325 a 0 dm
D326 a 0 dm
D327 a 0 dm
D328 a 0 dm
D329 a 0 dm
D330 a 0 dm
D331 a 0 dm
D332 a 0 dm
D333 a 0 dm
D334 a 0 dm
D335 a 0 dm
D336 a 0 dm
D337 a 0 dm
D338 a 0 dm
D339 a 0 dm
D340 a 0 dm
D341 a 0 dm
D342 a 0 dm
D343 a 0 dm
D344 a 0 dm
D345 a 0 dm
D346 a 0 dm
D347 a 0 dm
D348 a 0 dm
D349 a 0 dm
D350 a 0 dm
D351 a 0 dm
D352 a 0 dm
D353 a 0 dm
D354 a 0 dm
D355 a 0 dm
D356 a 0 dm
D357 a 0 dm
D358 a 0 dm
D359 a 0 dm
D360 a 0 dm
D361 a 0 dm
D362 a 0 dm
D363 a 0 dm
D364 a 0 dm
D365 a 0 dm
D366 a 0 dm
D367 a 0 dm
D368 a 0 dm
D369 a 0 dm
D370 a 0 dm
D371 a 0 dm
D372 a 0 dm
D373 a 0 dm
D374 a 0 dm
D375 a 0 dm
D376 a 0 dm
D377 a 0 dm
D378 a 0 dm
D379 a 0 dm
D380 a 0 dm
D381 a 0 dm
D382 a 0 dm
D383 a 0 dm
D384 a 0 dm
D385 a 0 dm
D386 a 0 dm
D387 a 0 dm
D388 a 0 dm
D389 a 0 dm
D390 a 0 dm
D391 a 0 dm
D392 a 0 dm
D393 a 0 dm
D394 a 0 dm
D395 a 0 dm
D396 a 0 dm
D397 a 0 dm
D398 a 0 dm
D399 a 0 dm
D400 a 0 dm
D401 a 0 dm
D402 a 0 dm
D403 a 0 dm
D404 a 0 dm
D405 a 0 dm
D406 a 0 dm
D407 a 0 dm
D408 a 0 dm
D409 a 0 dm
D410 a 0 dm
D411 a 0 dm
D412 a 0 dm
D413 a 0 dm
D414 a 0 dm
D415 a 0 dm
D416 a 0 dm
D417 a 0 dm
D418 a 0 dm
D419 a 0 dm
D420 a 0 dm
D421 a 0 dm
D422 a 0 dm
D423 a 0 dm
D424 a 0 dm
D425 a 0 dm
D426 a 0 dm
D427 a 0 dm
D428 a 0 dm
D429 a 0 dm
D430 a 0 dm
D431 a 0 dm
D432 a 0 dm
D433 a 0 dm
D434 a 0 dm
D435 a 0 dm
D436 a 0 dm
D437 a 0 dm
D438 a 0 dm
D439 a 0 dm
D440 a 0 dm
D441 a 0 dm
D442 a 0 dm
D443 a 0 dm
D444 a 0 dm
D445 a 0 dm
D446 a 0 dm
D447 a 0 dm
D448 a 0 dm
D449 a 0 dm
D450 a 0 dm
D451 a 0 dm
D452 a 0 dm
D453 a 0 dm
D454 a 0 dm
D455 a 0 dm
D456 a 0 dm
D457 a 0 dm
D458 a 0 dm
D459 a 0 dm
D460 a 0 dm
D461 a 0 dm
D462 a 0 dm
D463 a 0 dm
D464 a 0 dm
D465 a 0 dm
D466 a 0 dm
D467 a 0 dm
D468 a 0 dm
D469 a 0 dm
D470 a 0 dm
D471 a 0 dm
D472 a 0 dm
D473 a 0 dm
D474 a 0 dm
D475 a 0 dm
D476 a 0 dm
D477 a 0 dm
D478 a 0 dm
D479 a 0 dm
D480 a 0 dm
D481 a 0 dm
D482 a 0 dm
D483 a 0 dm
D484 a 0 dm
D485 a 0 dm
D486 a 0 dm
D487 a 0 dm
D488 a 0 dm
D489 a 0 dm
D490 a 0 dm
D491 a 0 dm
D492 a 0 dm
D493 a 0 dm
D494 a 0 dm
D495 a 0 dm
D496 a 0 dm
D497 a 0 dm
D498 a 0 dm
D499 a 0 dm
D500 a 0 dm
D501 a 0 dm
D502 a 0 dm
D503 a 0 dm
D504 a 0 dm
D505 a 0 dm
D506 a 0 dm
D507 a 0 dm
D508 a 0 dm
D509 a 0 dm
D510 a 0 dm
D511 a 0 dm
D512 a 0 dm
D513 a 0 dm
D514 a 0 dm
D515 a 0 dm
D516 a 0 dm
D517 a 0 dm
D518 a 0 dm
D519 a 0 dm
D520 a 0 dm
D521 a 0 dm
D522 a 0 dm
D523 a 0 dm
D524 a 0 dm
D525 a 0 dm
D526 a 0 dm
D527 a 0 dm
D528 a 0 dm
D529 a 0 dm
D530 a 0 dm
D531 a 0 dm
D532 a 0 dm
D533 a 0 dm
D534 a 0 dm
D535 a 0 dm
D536 a 0 dm
D537 a 0 dm
D538 a 0 dm
D539 a 0 dm
D540 a 0 dm
D541 a 0 dm
D542 a 0 dm
D543 a 0 dm
D544 a 0 dm
D545 a 0 dm
D546 a 0 dm
D547 a 0 dm
D548 a 0 dm
D549 a 0 dm
D550 a 0 dm
D551 a 0 dm
D552 a 0 dm
D553 a 0 dm
D554 a 0 dm
D555 a 0 dm
D556 a 0 dm
D557 a 0 dm
D558 a 0 dm
D559 a 0 dm
D560 a 0 dm
D561 a 0 dm
D562 a 0 dm
D563 a 0 dm
D564 a 0 dm
D565 a 0 dm
D566 a 0 dm
D567 a 0 dm
D568 a 0 dm
D569 a 0 dm
D570 a 0 dm
D571 a 0 dm
D572 a 0 dm
D573 a 0 dm
D574 a 0 dm
D575 a 0 dm
D576 a 0 dm
D577 a 0 dm
D578 a 0 dm
D579 a 0 dm
D580 a 0 dm
D581 a 0 dm
D582 a 0 dm
D583 a 0 dm
D584 a 0 dm
D585 a 0 dm
D586 a 0 dm
D587 a 0 dm
D588 a 0 dm
D589 a 0 dm
D590 a 0 dm
D591 a 0 dm
D592 a 0 dm
D593 a 0 dm
D594 a 0 dm
D595 a 0 dm
D596 a 0 dm
D597 a 0 dm
D598 a 0 dm
D599 a 0 dm
D600 a 0 dm
D601 a 0 dm
D602 a 0 dm
D603 a 0 dm
D604 a 0 dm
D605 a 0 dm
D606 a 0 dm
D607 a 0 dm
D608 a 0 dm
D609 a 0 dm
D610 a 0 dm
D611 a 0 dm
D612 a 0 dm
D613 a 0 dm
D614 a 0 dm
D615 a 0 dm
D616 a 0 dm
D617 a 0 dm
D618 a 0 dm
D619 a 0 dm
D620 a 0 dm
D621 a 0 dm
D622 a 0 dm
D623 a 0 dm
D624 a 0 dm
D625 a 0 dm
D626 a 0 dm
D627 a 0 dm
D628 a 0 dm
D629 a 0 dm
D630 a 0 dm
D631 a 0 dm
D632 a 0 dm
D633 a 0 dm
D634 a 0 dm
D635 a 0 dm
D636 a 0 dm
D637 a 0 dm
D638 a 0 dm
D639 a 0 dm
D640 a 0 dm
D641 a 0 dm
D642 a 0 dm
D643 a 0 dm
D644 a 0 dm
D645 a 0 dm
D646 a 0 dm
D647 a 0 dm
D648 a 0 dm
D649 a 0 dm
D650 a 0 dm
D651 a 0 dm
D652 a 0 dm
D653 a 0 dm
D654 a 0 dm
D655 a 0 dm
D656 a 0 dm
D657 a 0 dm
D658 a 0 dm
D659 a 0 dm
D660 a 0 dm
D661 a 0 dm
D662 a 0 dm
D663 a 0 dm
D664 a 0 dm
D665 a 0 dm
D666 a 0 dm
D667 a 0 dm
D668 a 0 dm
D669 a 0 dm
D670 a 0 dm
D671 a 0 dm
D672 a 0 dm
D673 a 0 dm
D674 a 0 dm
D675 a 0 dm
D676 a 0 dm
D677 a 0 dm
D678 a 0 dm
D679 a 0 dm
D680 a 0 dm
D681 a 0 dm
D682 a 0 dm
D683 a 0 dm
D684 a 0 dm
D685 a 0 dm
D686 a 0 dm
D687 a 0 dm
D688 a 0 dm
D689 a 0 dm
D690 a 0 dm
D691 a 0 dm
D692 a 0 dm
D693 a 0 dm
D694 a 0 dm
D695 a 0 dm
D696 a 0 dm
D697 a 0 dm
D698 a 0 dm
D699 a 0 dm
D700 a 0 dm
D701 a 0 dm
D702 a 0 dm
D703 a 0 dm
D704 a 0 dm
D705 a 0 dm
D706 a 0 dm
D707 a 0 dm
D708 a 0 dm
D709 a 0 dm
D710 a 0 dm
D711 a 0 dm
D712 a 0 dm
D713 a 0 dm
D714 a 0 dm
D715 a 0 dm
D716 a 0 dm
D717 a 0 dm
D718 a 0 dm
D719 a 0 dm
D720 a 0 dm
D721 a 0 dm
D722 a 0 dm
D723 a 0 dm
D724 a 0 dm
D725 a 0 dm
D726 a 0 dm
D727 a 0 dm
D728 a 0 dm
D729 a 0 dm
D730 a 0 dm
D731 a 0 dm
D732 a 0 dm
D733 a 0 dm
D734 a 0 dm
D735 a 0 dm
D736 a 0 dm
D737 a 0 dm
D738 a 0 dm
D739 a 0 dm
D740 a 0 dm
D741 a 0 dm
D742 a 0 dm
D743 a 0 dm
D744 a 0 dm
D745 a 0 dm
D746 a 0 dm
D747 a 0 dm
D748 a 0 dm
D749 a 0 dm
D750 a 0 dm
D751 a 0 dm
D752 a 0 dm
D753 a 0 dm
D754 a 0 dm
D755 a 0 dm
D756 a 0 dm
D757 a 0 dm
D758 a 0 dm
D759 a 0 dm
D760 a 0 dm
D761 a 0 dm
D762 a 0 dm
D763 a 0 dm
D764 a 0 dm
D765 a 0 dm
D766 a 0 dm
D767 a 0 dm
D768 a 0 dm
D769 a 0 dm
D770 a 0 dm
D771 a 0 dm
D772 a 0 dm
D773 a 0 dm
D774 a 0 dm
D775 a 0 dm
D776 a 0 dm
D777 a 0 dm
D778 a 0 dm
D779 a 0 dm
D780 a 0 dm
D781 a 0 dm
D782 a 0 dm
D783 a 0 dm
D784 a 0 dm
D785 a 0 dm
D786 a 0 dm
D787 a 0 dm
D788 a 0 dm
D789 a 0 dm
D790 a 0 dm
D791 a 0 dm
D792 a 0 dm
D793 a 0 dm
D794 a 0 dm
D795 a 0 dm
D796 a 0 dm
D797 a 0 dm
D798 a 0 dm
D799 a 0 dm
D800 a 0 dm
D801 a 0 dm
D802 a 0 dm
D803 a 0 dm
D804 a 0 dm
D805 a 0 dm
D806 a 0 dm
D807 a 0 dm
D808 a 0 dm
D809 a 0 dm
D810 a 0 dm
D811 a 0 dm
D812 a 0 dm
D813 a 0 dm
D814 a 0 dm
D815 a 0 dm
D816 a 0 dm
D817 a 0 dm
D818 a 0 dm
D819 a 0 dm
D820 a 0 dm
D821 a 0 dm
D822 a 0 dm
D823 a 0 dm
D824 a 0 dm
D825 a 0 dm
D826 a 0 dm
D827 a 0 dm
D828 a 0 dm
D829 a 0 dm
D830 a 0 dm
D831 a 0 dm
D832 a 0 dm
D833 a 0 dm
D834 a 0 dm
D835 a 0 dm
D836 a 0 dm
D837 a 0 dm
D838 a 0 dm
D839 a 0 dm
D840 a 0 dm
D841 a 0 dm
D842 a 0 dm
D843 a 0 dm
D844 a 0 dm
D845 a 0 dm
D846 a 0 dm
D847 a 0 dm
D848 a 0 dm
D849 a 0 dm
D850 a 0 dm
D851 a 0 dm
D852 a 0 dm
D853 a 0 dm
D854 a 0 dm
D855 a 0 dm
D856 a 0 dm
D857 a 0 dm
D858 a 0 dm
D859 a 0 dm
D860 a 0 dm
D861 a 0 dm
D862 a 0 dm
D863 a 0 dm
D864 a 0 dm
D865 a 0 dm
D866 a 0 dm
D867 a 0 dm
D868 a 0 dm
D869 a 0 dm
D870 a 0 dm
D871 a 0 dm
D872 a 0 dm
D873 a 0 dm
D874 a 0 dm
D875 a 0 dm
D876 a 0 dm
D877 a 0 dm
D878 a 0 dm
D879 a 0 dm
D880 a 0 dm
D881 a 0 dm
D882 a 0 dm
D883 a 0 dm
D884 a 0 dm
D885 a 0 dm
D886 a 0 dm
D887 a 0 dm
D888 a 0 dm
D889 a 0 dm
D890 a 0 dm
D891 a 0 dm
D892 a 0 dm
D893 a 0 dm
D894 a 0 dm
D895 a 0 dm
D896 a 0 dm
D897 a 0 dm
D898 a 0 dm
D899 a 0 dm
D900 a 0 dm
D901 a 0 dm
D902 a 0 dm
D903 a 0 dm
D904 a 0 dm
D905 a 0 dm
D906 a 0 dm
D907 a 0 dm
D908 a 0 dm
D909 a 0 dm
D910 a 0 dm
D911 a 0 dm
D912 a 0 dm
D913 a 0 dm
D914 a 0 dm
D915 a 0 dm
D916 a 0 dm
D917 a 0 dm
D918 a 0 dm
D919 a 0 dm
D920 a 0 dm
D921 a 0 dm
D922 a 0 dm
D923 a 0 dm
D924 a 0 dm
D925 a 0 dm
D926 a 0 dm
D927 a 0 dm
D928 a 0 dm
D929 a 0 dm
D930 a 0 dm
D931 a 0 dm
D932 a 0 dm
D933 a 0 dm
D934 a 0 dm
D935 a 0 dm
D936 a 0 dm
D937 a 0 dm
D938 a 0 dm
D939 a 0 dm
D940 a 0 dm
D941 a 0 dm
D942 a 0 dm
D943 a 0 dm
D944 a 0 dm
D945 a 0 dm
D946 a 0 dm
D947 a 0 dm
D948 a 0 dm
D949 a 0 dm
D950 a 0 dm
D951 a 0 dm
D952 a 0 dm
D953 a 0 dm
D954 a 0 dm
D955 a 0 dm
D956 a 0 dm
D957 a 0 dm
D958 a 0 dm
D959 a 0 dm
D960 a 0 dm
D961 a 0 dm
D962 a 0 dm
D963 a 0 dm
D964 a 0 dm
D965 a 0 dm
D966 a 0 dm
D967 a 0 dm
D968 a 0 dm
D969 a 0 dm
D970 a 0 dm
D971 a 0 dm
D972 a 0 dm
D973 a 0 dm
D974 a 0 dm
D975 a 0 dm
D976 a 0 dm
D977 a 0 dm
D978 a 0 dm
D979 a 0 dm
D980 a 0 dm
D981 a 0 dm
D982 a 0 dm
D983 a 0 dm
D984 a 0 dm
D985 a 0 dm
D986 a 0 dm
D987 a 0 dm
D988 a 0 dm
D989 a 0 dm
D990 a 0 dm
D991 a 0 dm
D992 a 0 dm
D993 a 0 dm
D994 a 0 dm
D995 a 0 dm
D996 a 0 dm
D997 a 0 dm
D998 a 0 dm
D999 a 0 dm
D1000 a 0 dm
.dc V1 0 3.125 0.0625
.end
