Diode RC mesh 12x12, slow pulse drive, 2000 steps
* bench.id: perf_med_diode_mesh_tran_12x12
* bench.group: performance
* bench.title: Diode RC mesh 12x12, slow pulse drive, 2000 steps
* bench.probes: v(n0_0), v(n6_6), v(n11_11), i(v1)
* bench.tol.norm: 5e-3
* bench.expect: match
* bench.ref: reltol=1e-6 abstol=1e-15 vntol=1e-9
* bench.ref.tmax: 1.25n
* bench.ng.solver: both
* bench.timing: yes
* bench.size: 146
* bench.est_rss_mib: 15
* bench.tags: nonlinear, tran, mesh, diode, medium
* bench.note: nonlinear 146-unknown 2-D transient: every step is a Newton solve with 2-D fill and 144 exponential devices; tstop is 2000.5 steps so the last step is a legitimate half step
.model dm D(IS=1e-14 N=1)
V1 s 0 PULSE(0 3 100n 500n 500n 800n 2u)
Rin s n0_0 100
D0_0 n0_0 0 dm
C0_0 n0_0 0 1p
Rh0_0 n0_0 n0_1 1k
Rv0_0 n0_0 n1_0 1k
D0_1 n0_1 0 dm
C0_1 n0_1 0 1p
Rh0_1 n0_1 n0_2 1k
Rv0_1 n0_1 n1_1 1k
D0_2 n0_2 0 dm
C0_2 n0_2 0 1p
Rh0_2 n0_2 n0_3 1k
Rv0_2 n0_2 n1_2 1k
D0_3 n0_3 0 dm
C0_3 n0_3 0 1p
Rh0_3 n0_3 n0_4 1k
Rv0_3 n0_3 n1_3 1k
D0_4 n0_4 0 dm
C0_4 n0_4 0 1p
Rh0_4 n0_4 n0_5 1k
Rv0_4 n0_4 n1_4 1k
D0_5 n0_5 0 dm
C0_5 n0_5 0 1p
Rh0_5 n0_5 n0_6 1k
Rv0_5 n0_5 n1_5 1k
D0_6 n0_6 0 dm
C0_6 n0_6 0 1p
Rh0_6 n0_6 n0_7 1k
Rv0_6 n0_6 n1_6 1k
D0_7 n0_7 0 dm
C0_7 n0_7 0 1p
Rh0_7 n0_7 n0_8 1k
Rv0_7 n0_7 n1_7 1k
D0_8 n0_8 0 dm
C0_8 n0_8 0 1p
Rh0_8 n0_8 n0_9 1k
Rv0_8 n0_8 n1_8 1k
D0_9 n0_9 0 dm
C0_9 n0_9 0 1p
Rh0_9 n0_9 n0_10 1k
Rv0_9 n0_9 n1_9 1k
D0_10 n0_10 0 dm
C0_10 n0_10 0 1p
Rh0_10 n0_10 n0_11 1k
Rv0_10 n0_10 n1_10 1k
D0_11 n0_11 0 dm
C0_11 n0_11 0 1p
Rv0_11 n0_11 n1_11 1k
D1_0 n1_0 0 dm
C1_0 n1_0 0 1p
Rh1_0 n1_0 n1_1 1k
Rv1_0 n1_0 n2_0 1k
D1_1 n1_1 0 dm
C1_1 n1_1 0 1p
Rh1_1 n1_1 n1_2 1k
Rv1_1 n1_1 n2_1 1k
D1_2 n1_2 0 dm
C1_2 n1_2 0 1p
Rh1_2 n1_2 n1_3 1k
Rv1_2 n1_2 n2_2 1k
D1_3 n1_3 0 dm
C1_3 n1_3 0 1p
Rh1_3 n1_3 n1_4 1k
Rv1_3 n1_3 n2_3 1k
D1_4 n1_4 0 dm
C1_4 n1_4 0 1p
Rh1_4 n1_4 n1_5 1k
Rv1_4 n1_4 n2_4 1k
D1_5 n1_5 0 dm
C1_5 n1_5 0 1p
Rh1_5 n1_5 n1_6 1k
Rv1_5 n1_5 n2_5 1k
D1_6 n1_6 0 dm
C1_6 n1_6 0 1p
Rh1_6 n1_6 n1_7 1k
Rv1_6 n1_6 n2_6 1k
D1_7 n1_7 0 dm
C1_7 n1_7 0 1p
Rh1_7 n1_7 n1_8 1k
Rv1_7 n1_7 n2_7 1k
D1_8 n1_8 0 dm
C1_8 n1_8 0 1p
Rh1_8 n1_8 n1_9 1k
Rv1_8 n1_8 n2_8 1k
D1_9 n1_9 0 dm
C1_9 n1_9 0 1p
Rh1_9 n1_9 n1_10 1k
Rv1_9 n1_9 n2_9 1k
D1_10 n1_10 0 dm
C1_10 n1_10 0 1p
Rh1_10 n1_10 n1_11 1k
Rv1_10 n1_10 n2_10 1k
D1_11 n1_11 0 dm
C1_11 n1_11 0 1p
Rv1_11 n1_11 n2_11 1k
D2_0 n2_0 0 dm
C2_0 n2_0 0 1p
Rh2_0 n2_0 n2_1 1k
Rv2_0 n2_0 n3_0 1k
D2_1 n2_1 0 dm
C2_1 n2_1 0 1p
Rh2_1 n2_1 n2_2 1k
Rv2_1 n2_1 n3_1 1k
D2_2 n2_2 0 dm
C2_2 n2_2 0 1p
Rh2_2 n2_2 n2_3 1k
Rv2_2 n2_2 n3_2 1k
D2_3 n2_3 0 dm
C2_3 n2_3 0 1p
Rh2_3 n2_3 n2_4 1k
Rv2_3 n2_3 n3_3 1k
D2_4 n2_4 0 dm
C2_4 n2_4 0 1p
Rh2_4 n2_4 n2_5 1k
Rv2_4 n2_4 n3_4 1k
D2_5 n2_5 0 dm
C2_5 n2_5 0 1p
Rh2_5 n2_5 n2_6 1k
Rv2_5 n2_5 n3_5 1k
D2_6 n2_6 0 dm
C2_6 n2_6 0 1p
Rh2_6 n2_6 n2_7 1k
Rv2_6 n2_6 n3_6 1k
D2_7 n2_7 0 dm
C2_7 n2_7 0 1p
Rh2_7 n2_7 n2_8 1k
Rv2_7 n2_7 n3_7 1k
D2_8 n2_8 0 dm
C2_8 n2_8 0 1p
Rh2_8 n2_8 n2_9 1k
Rv2_8 n2_8 n3_8 1k
D2_9 n2_9 0 dm
C2_9 n2_9 0 1p
Rh2_9 n2_9 n2_10 1k
Rv2_9 n2_9 n3_9 1k
D2_10 n2_10 0 dm
C2_10 n2_10 0 1p
Rh2_10 n2_10 n2_11 1k
Rv2_10 n2_10 n3_10 1k
D2_11 n2_11 0 dm
C2_11 n2_11 0 1p
Rv2_11 n2_11 n3_11 1k
D3_0 n3_0 0 dm
C3_0 n3_0 0 1p
Rh3_0 n3_0 n3_1 1k
Rv3_0 n3_0 n4_0 1k
D3_1 n3_1 0 dm
C3_1 n3_1 0 1p
Rh3_1 n3_1 n3_2 1k
Rv3_1 n3_1 n4_1 1k
D3_2 n3_2 0 dm
C3_2 n3_2 0 1p
Rh3_2 n3_2 n3_3 1k
Rv3_2 n3_2 n4_2 1k
D3_3 n3_3 0 dm
C3_3 n3_3 0 1p
Rh3_3 n3_3 n3_4 1k
Rv3_3 n3_3 n4_3 1k
D3_4 n3_4 0 dm
C3_4 n3_4 0 1p
Rh3_4 n3_4 n3_5 1k
Rv3_4 n3_4 n4_4 1k
D3_5 n3_5 0 dm
C3_5 n3_5 0 1p
Rh3_5 n3_5 n3_6 1k
Rv3_5 n3_5 n4_5 1k
D3_6 n3_6 0 dm
C3_6 n3_6 0 1p
Rh3_6 n3_6 n3_7 1k
Rv3_6 n3_6 n4_6 1k
D3_7 n3_7 0 dm
C3_7 n3_7 0 1p
Rh3_7 n3_7 n3_8 1k
Rv3_7 n3_7 n4_7 1k
D3_8 n3_8 0 dm
C3_8 n3_8 0 1p
Rh3_8 n3_8 n3_9 1k
Rv3_8 n3_8 n4_8 1k
D3_9 n3_9 0 dm
C3_9 n3_9 0 1p
Rh3_9 n3_9 n3_10 1k
Rv3_9 n3_9 n4_9 1k
D3_10 n3_10 0 dm
C3_10 n3_10 0 1p
Rh3_10 n3_10 n3_11 1k
Rv3_10 n3_10 n4_10 1k
D3_11 n3_11 0 dm
C3_11 n3_11 0 1p
Rv3_11 n3_11 n4_11 1k
D4_0 n4_0 0 dm
C4_0 n4_0 0 1p
Rh4_0 n4_0 n4_1 1k
Rv4_0 n4_0 n5_0 1k
D4_1 n4_1 0 dm
C4_1 n4_1 0 1p
Rh4_1 n4_1 n4_2 1k
Rv4_1 n4_1 n5_1 1k
D4_2 n4_2 0 dm
C4_2 n4_2 0 1p
Rh4_2 n4_2 n4_3 1k
Rv4_2 n4_2 n5_2 1k
D4_3 n4_3 0 dm
C4_3 n4_3 0 1p
Rh4_3 n4_3 n4_4 1k
Rv4_3 n4_3 n5_3 1k
D4_4 n4_4 0 dm
C4_4 n4_4 0 1p
Rh4_4 n4_4 n4_5 1k
Rv4_4 n4_4 n5_4 1k
D4_5 n4_5 0 dm
C4_5 n4_5 0 1p
Rh4_5 n4_5 n4_6 1k
Rv4_5 n4_5 n5_5 1k
D4_6 n4_6 0 dm
C4_6 n4_6 0 1p
Rh4_6 n4_6 n4_7 1k
Rv4_6 n4_6 n5_6 1k
D4_7 n4_7 0 dm
C4_7 n4_7 0 1p
Rh4_7 n4_7 n4_8 1k
Rv4_7 n4_7 n5_7 1k
D4_8 n4_8 0 dm
C4_8 n4_8 0 1p
Rh4_8 n4_8 n4_9 1k
Rv4_8 n4_8 n5_8 1k
D4_9 n4_9 0 dm
C4_9 n4_9 0 1p
Rh4_9 n4_9 n4_10 1k
Rv4_9 n4_9 n5_9 1k
D4_10 n4_10 0 dm
C4_10 n4_10 0 1p
Rh4_10 n4_10 n4_11 1k
Rv4_10 n4_10 n5_10 1k
D4_11 n4_11 0 dm
C4_11 n4_11 0 1p
Rv4_11 n4_11 n5_11 1k
D5_0 n5_0 0 dm
C5_0 n5_0 0 1p
Rh5_0 n5_0 n5_1 1k
Rv5_0 n5_0 n6_0 1k
D5_1 n5_1 0 dm
C5_1 n5_1 0 1p
Rh5_1 n5_1 n5_2 1k
Rv5_1 n5_1 n6_1 1k
D5_2 n5_2 0 dm
C5_2 n5_2 0 1p
Rh5_2 n5_2 n5_3 1k
Rv5_2 n5_2 n6_2 1k
D5_3 n5_3 0 dm
C5_3 n5_3 0 1p
Rh5_3 n5_3 n5_4 1k
Rv5_3 n5_3 n6_3 1k
D5_4 n5_4 0 dm
C5_4 n5_4 0 1p
Rh5_4 n5_4 n5_5 1k
Rv5_4 n5_4 n6_4 1k
D5_5 n5_5 0 dm
C5_5 n5_5 0 1p
Rh5_5 n5_5 n5_6 1k
Rv5_5 n5_5 n6_5 1k
D5_6 n5_6 0 dm
C5_6 n5_6 0 1p
Rh5_6 n5_6 n5_7 1k
Rv5_6 n5_6 n6_6 1k
D5_7 n5_7 0 dm
C5_7 n5_7 0 1p
Rh5_7 n5_7 n5_8 1k
Rv5_7 n5_7 n6_7 1k
D5_8 n5_8 0 dm
C5_8 n5_8 0 1p
Rh5_8 n5_8 n5_9 1k
Rv5_8 n5_8 n6_8 1k
D5_9 n5_9 0 dm
C5_9 n5_9 0 1p
Rh5_9 n5_9 n5_10 1k
Rv5_9 n5_9 n6_9 1k
D5_10 n5_10 0 dm
C5_10 n5_10 0 1p
Rh5_10 n5_10 n5_11 1k
Rv5_10 n5_10 n6_10 1k
D5_11 n5_11 0 dm
C5_11 n5_11 0 1p
Rv5_11 n5_11 n6_11 1k
D6_0 n6_0 0 dm
C6_0 n6_0 0 1p
Rh6_0 n6_0 n6_1 1k
Rv6_0 n6_0 n7_0 1k
D6_1 n6_1 0 dm
C6_1 n6_1 0 1p
Rh6_1 n6_1 n6_2 1k
Rv6_1 n6_1 n7_1 1k
D6_2 n6_2 0 dm
C6_2 n6_2 0 1p
Rh6_2 n6_2 n6_3 1k
Rv6_2 n6_2 n7_2 1k
D6_3 n6_3 0 dm
C6_3 n6_3 0 1p
Rh6_3 n6_3 n6_4 1k
Rv6_3 n6_3 n7_3 1k
D6_4 n6_4 0 dm
C6_4 n6_4 0 1p
Rh6_4 n6_4 n6_5 1k
Rv6_4 n6_4 n7_4 1k
D6_5 n6_5 0 dm
C6_5 n6_5 0 1p
Rh6_5 n6_5 n6_6 1k
Rv6_5 n6_5 n7_5 1k
D6_6 n6_6 0 dm
C6_6 n6_6 0 1p
Rh6_6 n6_6 n6_7 1k
Rv6_6 n6_6 n7_6 1k
D6_7 n6_7 0 dm
C6_7 n6_7 0 1p
Rh6_7 n6_7 n6_8 1k
Rv6_7 n6_7 n7_7 1k
D6_8 n6_8 0 dm
C6_8 n6_8 0 1p
Rh6_8 n6_8 n6_9 1k
Rv6_8 n6_8 n7_8 1k
D6_9 n6_9 0 dm
C6_9 n6_9 0 1p
Rh6_9 n6_9 n6_10 1k
Rv6_9 n6_9 n7_9 1k
D6_10 n6_10 0 dm
C6_10 n6_10 0 1p
Rh6_10 n6_10 n6_11 1k
Rv6_10 n6_10 n7_10 1k
D6_11 n6_11 0 dm
C6_11 n6_11 0 1p
Rv6_11 n6_11 n7_11 1k
D7_0 n7_0 0 dm
C7_0 n7_0 0 1p
Rh7_0 n7_0 n7_1 1k
Rv7_0 n7_0 n8_0 1k
D7_1 n7_1 0 dm
C7_1 n7_1 0 1p
Rh7_1 n7_1 n7_2 1k
Rv7_1 n7_1 n8_1 1k
D7_2 n7_2 0 dm
C7_2 n7_2 0 1p
Rh7_2 n7_2 n7_3 1k
Rv7_2 n7_2 n8_2 1k
D7_3 n7_3 0 dm
C7_3 n7_3 0 1p
Rh7_3 n7_3 n7_4 1k
Rv7_3 n7_3 n8_3 1k
D7_4 n7_4 0 dm
C7_4 n7_4 0 1p
Rh7_4 n7_4 n7_5 1k
Rv7_4 n7_4 n8_4 1k
D7_5 n7_5 0 dm
C7_5 n7_5 0 1p
Rh7_5 n7_5 n7_6 1k
Rv7_5 n7_5 n8_5 1k
D7_6 n7_6 0 dm
C7_6 n7_6 0 1p
Rh7_6 n7_6 n7_7 1k
Rv7_6 n7_6 n8_6 1k
D7_7 n7_7 0 dm
C7_7 n7_7 0 1p
Rh7_7 n7_7 n7_8 1k
Rv7_7 n7_7 n8_7 1k
D7_8 n7_8 0 dm
C7_8 n7_8 0 1p
Rh7_8 n7_8 n7_9 1k
Rv7_8 n7_8 n8_8 1k
D7_9 n7_9 0 dm
C7_9 n7_9 0 1p
Rh7_9 n7_9 n7_10 1k
Rv7_9 n7_9 n8_9 1k
D7_10 n7_10 0 dm
C7_10 n7_10 0 1p
Rh7_10 n7_10 n7_11 1k
Rv7_10 n7_10 n8_10 1k
D7_11 n7_11 0 dm
C7_11 n7_11 0 1p
Rv7_11 n7_11 n8_11 1k
D8_0 n8_0 0 dm
C8_0 n8_0 0 1p
Rh8_0 n8_0 n8_1 1k
Rv8_0 n8_0 n9_0 1k
D8_1 n8_1 0 dm
C8_1 n8_1 0 1p
Rh8_1 n8_1 n8_2 1k
Rv8_1 n8_1 n9_1 1k
D8_2 n8_2 0 dm
C8_2 n8_2 0 1p
Rh8_2 n8_2 n8_3 1k
Rv8_2 n8_2 n9_2 1k
D8_3 n8_3 0 dm
C8_3 n8_3 0 1p
Rh8_3 n8_3 n8_4 1k
Rv8_3 n8_3 n9_3 1k
D8_4 n8_4 0 dm
C8_4 n8_4 0 1p
Rh8_4 n8_4 n8_5 1k
Rv8_4 n8_4 n9_4 1k
D8_5 n8_5 0 dm
C8_5 n8_5 0 1p
Rh8_5 n8_5 n8_6 1k
Rv8_5 n8_5 n9_5 1k
D8_6 n8_6 0 dm
C8_6 n8_6 0 1p
Rh8_6 n8_6 n8_7 1k
Rv8_6 n8_6 n9_6 1k
D8_7 n8_7 0 dm
C8_7 n8_7 0 1p
Rh8_7 n8_7 n8_8 1k
Rv8_7 n8_7 n9_7 1k
D8_8 n8_8 0 dm
C8_8 n8_8 0 1p
Rh8_8 n8_8 n8_9 1k
Rv8_8 n8_8 n9_8 1k
D8_9 n8_9 0 dm
C8_9 n8_9 0 1p
Rh8_9 n8_9 n8_10 1k
Rv8_9 n8_9 n9_9 1k
D8_10 n8_10 0 dm
C8_10 n8_10 0 1p
Rh8_10 n8_10 n8_11 1k
Rv8_10 n8_10 n9_10 1k
D8_11 n8_11 0 dm
C8_11 n8_11 0 1p
Rv8_11 n8_11 n9_11 1k
D9_0 n9_0 0 dm
C9_0 n9_0 0 1p
Rh9_0 n9_0 n9_1 1k
Rv9_0 n9_0 n10_0 1k
D9_1 n9_1 0 dm
C9_1 n9_1 0 1p
Rh9_1 n9_1 n9_2 1k
Rv9_1 n9_1 n10_1 1k
D9_2 n9_2 0 dm
C9_2 n9_2 0 1p
Rh9_2 n9_2 n9_3 1k
Rv9_2 n9_2 n10_2 1k
D9_3 n9_3 0 dm
C9_3 n9_3 0 1p
Rh9_3 n9_3 n9_4 1k
Rv9_3 n9_3 n10_3 1k
D9_4 n9_4 0 dm
C9_4 n9_4 0 1p
Rh9_4 n9_4 n9_5 1k
Rv9_4 n9_4 n10_4 1k
D9_5 n9_5 0 dm
C9_5 n9_5 0 1p
Rh9_5 n9_5 n9_6 1k
Rv9_5 n9_5 n10_5 1k
D9_6 n9_6 0 dm
C9_6 n9_6 0 1p
Rh9_6 n9_6 n9_7 1k
Rv9_6 n9_6 n10_6 1k
D9_7 n9_7 0 dm
C9_7 n9_7 0 1p
Rh9_7 n9_7 n9_8 1k
Rv9_7 n9_7 n10_7 1k
D9_8 n9_8 0 dm
C9_8 n9_8 0 1p
Rh9_8 n9_8 n9_9 1k
Rv9_8 n9_8 n10_8 1k
D9_9 n9_9 0 dm
C9_9 n9_9 0 1p
Rh9_9 n9_9 n9_10 1k
Rv9_9 n9_9 n10_9 1k
D9_10 n9_10 0 dm
C9_10 n9_10 0 1p
Rh9_10 n9_10 n9_11 1k
Rv9_10 n9_10 n10_10 1k
D9_11 n9_11 0 dm
C9_11 n9_11 0 1p
Rv9_11 n9_11 n10_11 1k
D10_0 n10_0 0 dm
C10_0 n10_0 0 1p
Rh10_0 n10_0 n10_1 1k
Rv10_0 n10_0 n11_0 1k
D10_1 n10_1 0 dm
C10_1 n10_1 0 1p
Rh10_1 n10_1 n10_2 1k
Rv10_1 n10_1 n11_1 1k
D10_2 n10_2 0 dm
C10_2 n10_2 0 1p
Rh10_2 n10_2 n10_3 1k
Rv10_2 n10_2 n11_2 1k
D10_3 n10_3 0 dm
C10_3 n10_3 0 1p
Rh10_3 n10_3 n10_4 1k
Rv10_3 n10_3 n11_3 1k
D10_4 n10_4 0 dm
C10_4 n10_4 0 1p
Rh10_4 n10_4 n10_5 1k
Rv10_4 n10_4 n11_4 1k
D10_5 n10_5 0 dm
C10_5 n10_5 0 1p
Rh10_5 n10_5 n10_6 1k
Rv10_5 n10_5 n11_5 1k
D10_6 n10_6 0 dm
C10_6 n10_6 0 1p
Rh10_6 n10_6 n10_7 1k
Rv10_6 n10_6 n11_6 1k
D10_7 n10_7 0 dm
C10_7 n10_7 0 1p
Rh10_7 n10_7 n10_8 1k
Rv10_7 n10_7 n11_7 1k
D10_8 n10_8 0 dm
C10_8 n10_8 0 1p
Rh10_8 n10_8 n10_9 1k
Rv10_8 n10_8 n11_8 1k
D10_9 n10_9 0 dm
C10_9 n10_9 0 1p
Rh10_9 n10_9 n10_10 1k
Rv10_9 n10_9 n11_9 1k
D10_10 n10_10 0 dm
C10_10 n10_10 0 1p
Rh10_10 n10_10 n10_11 1k
Rv10_10 n10_10 n11_10 1k
D10_11 n10_11 0 dm
C10_11 n10_11 0 1p
Rv10_11 n10_11 n11_11 1k
D11_0 n11_0 0 dm
C11_0 n11_0 0 1p
Rh11_0 n11_0 n11_1 1k
D11_1 n11_1 0 dm
C11_1 n11_1 0 1p
Rh11_1 n11_1 n11_2 1k
D11_2 n11_2 0 dm
C11_2 n11_2 0 1p
Rh11_2 n11_2 n11_3 1k
D11_3 n11_3 0 dm
C11_3 n11_3 0 1p
Rh11_3 n11_3 n11_4 1k
D11_4 n11_4 0 dm
C11_4 n11_4 0 1p
Rh11_4 n11_4 n11_5 1k
D11_5 n11_5 0 dm
C11_5 n11_5 0 1p
Rh11_5 n11_5 n11_6 1k
D11_6 n11_6 0 dm
C11_6 n11_6 0 1p
Rh11_6 n11_6 n11_7 1k
D11_7 n11_7 0 dm
C11_7 n11_7 0 1p
Rh11_7 n11_7 n11_8 1k
D11_8 n11_8 0 dm
C11_8 n11_8 0 1p
Rh11_8 n11_8 n11_9 1k
D11_9 n11_9 0 dm
C11_9 n11_9 0 1p
Rh11_9 n11_9 n11_10 1k
D11_10 n11_10 0 dm
C11_10 n11_10 0 1p
Rh11_10 n11_10 n11_11 1k
D11_11 n11_11 0 dm
C11_11 n11_11 0 1p
.tran 5n 10.0025u
.end
