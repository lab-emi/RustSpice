3-D resistor mesh 11x11x11, 1k edges, 50k leak per node, corner driven, one operating point
* bench.id: perf_scal_mesh3d_dc_n11
* bench.group: performance
* bench.title: 3-D resistor mesh 11x11x11, 1k edges, 50k leak per node, corner driven, one operating point
* bench.probes: v(n5_5_5), v(n10_10_10), v(n1_0_0), v(n0_0_10), i(v1)
* bench.tol.rel: 1e-6
* bench.tol.abs: 1e-9
* bench.expect: match
* bench.oracle: dc_linear
* bench.ng.solver: both
* bench.timing: yes
* bench.size: 1332
* bench.est_rss_mib: 196
* bench.tags: linear, op, mesh, mesh3d, faer_tier, memory, family:perf_scal_mesh3d_dc
* bench.note: 1332 unknowns; scipy sparse LU agrees with both tools at all 1331 nodes to 3.6e-15 V (v(n5_5_5)=0.248730 V, v(n10_10_10)=0.162389 V, i(v1)=-7.7175 mA); measured on an idle core: rustspice e2e 376 ms (compile 360 ms, solve 13.2 ms, VmHWM 151 MiB = 116 KB per unknown) vs ngspice KLU 39.3 ms (24 MiB) and SPARSE 334 ms
V1 n0_0_0 0 5
Rx0_0_0 n0_0_0 n1_0_0 1k
Ry0_0_0 n0_0_0 n0_1_0 1k
Rz0_0_0 n0_0_0 n0_0_1 1k
Rg0_0_0 n0_0_0 0 50k
Rx0_0_1 n0_0_1 n1_0_1 1k
Ry0_0_1 n0_0_1 n0_1_1 1k
Rz0_0_1 n0_0_1 n0_0_2 1k
Rg0_0_1 n0_0_1 0 50k
Rx0_0_2 n0_0_2 n1_0_2 1k
Ry0_0_2 n0_0_2 n0_1_2 1k
Rz0_0_2 n0_0_2 n0_0_3 1k
Rg0_0_2 n0_0_2 0 50k
Rx0_0_3 n0_0_3 n1_0_3 1k
Ry0_0_3 n0_0_3 n0_1_3 1k
Rz0_0_3 n0_0_3 n0_0_4 1k
Rg0_0_3 n0_0_3 0 50k
Rx0_0_4 n0_0_4 n1_0_4 1k
Ry0_0_4 n0_0_4 n0_1_4 1k
Rz0_0_4 n0_0_4 n0_0_5 1k
Rg0_0_4 n0_0_4 0 50k
Rx0_0_5 n0_0_5 n1_0_5 1k
Ry0_0_5 n0_0_5 n0_1_5 1k
Rz0_0_5 n0_0_5 n0_0_6 1k
Rg0_0_5 n0_0_5 0 50k
Rx0_0_6 n0_0_6 n1_0_6 1k
Ry0_0_6 n0_0_6 n0_1_6 1k
Rz0_0_6 n0_0_6 n0_0_7 1k
Rg0_0_6 n0_0_6 0 50k
Rx0_0_7 n0_0_7 n1_0_7 1k
Ry0_0_7 n0_0_7 n0_1_7 1k
Rz0_0_7 n0_0_7 n0_0_8 1k
Rg0_0_7 n0_0_7 0 50k
Rx0_0_8 n0_0_8 n1_0_8 1k
Ry0_0_8 n0_0_8 n0_1_8 1k
Rz0_0_8 n0_0_8 n0_0_9 1k
Rg0_0_8 n0_0_8 0 50k
Rx0_0_9 n0_0_9 n1_0_9 1k
Ry0_0_9 n0_0_9 n0_1_9 1k
Rz0_0_9 n0_0_9 n0_0_10 1k
Rg0_0_9 n0_0_9 0 50k
Rx0_0_10 n0_0_10 n1_0_10 1k
Ry0_0_10 n0_0_10 n0_1_10 1k
Rg0_0_10 n0_0_10 0 50k
Rx0_1_0 n0_1_0 n1_1_0 1k
Ry0_1_0 n0_1_0 n0_2_0 1k
Rz0_1_0 n0_1_0 n0_1_1 1k
Rg0_1_0 n0_1_0 0 50k
Rx0_1_1 n0_1_1 n1_1_1 1k
Ry0_1_1 n0_1_1 n0_2_1 1k
Rz0_1_1 n0_1_1 n0_1_2 1k
Rg0_1_1 n0_1_1 0 50k
Rx0_1_2 n0_1_2 n1_1_2 1k
Ry0_1_2 n0_1_2 n0_2_2 1k
Rz0_1_2 n0_1_2 n0_1_3 1k
Rg0_1_2 n0_1_2 0 50k
Rx0_1_3 n0_1_3 n1_1_3 1k
Ry0_1_3 n0_1_3 n0_2_3 1k
Rz0_1_3 n0_1_3 n0_1_4 1k
Rg0_1_3 n0_1_3 0 50k
Rx0_1_4 n0_1_4 n1_1_4 1k
Ry0_1_4 n0_1_4 n0_2_4 1k
Rz0_1_4 n0_1_4 n0_1_5 1k
Rg0_1_4 n0_1_4 0 50k
Rx0_1_5 n0_1_5 n1_1_5 1k
Ry0_1_5 n0_1_5 n0_2_5 1k
Rz0_1_5 n0_1_5 n0_1_6 1k
Rg0_1_5 n0_1_5 0 50k
Rx0_1_6 n0_1_6 n1_1_6 1k
Ry0_1_6 n0_1_6 n0_2_6 1k
Rz0_1_6 n0_1_6 n0_1_7 1k
Rg0_1_6 n0_1_6 0 50k
Rx0_1_7 n0_1_7 n1_1_7 1k
Ry0_1_7 n0_1_7 n0_2_7 1k
Rz0_1_7 n0_1_7 n0_1_8 1k
Rg0_1_7 n0_1_7 0 50k
Rx0_1_8 n0_1_8 n1_1_8 1k
Ry0_1_8 n0_1_8 n0_2_8 1k
Rz0_1_8 n0_1_8 n0_1_9 1k
Rg0_1_8 n0_1_8 0 50k
Rx0_1_9 n0_1_9 n1_1_9 1k
Ry0_1_9 n0_1_9 n0_2_9 1k
Rz0_1_9 n0_1_9 n0_1_10 1k
Rg0_1_9 n0_1_9 0 50k
Rx0_1_10 n0_1_10 n1_1_10 1k
Ry0_1_10 n0_1_10 n0_2_10 1k
Rg0_1_10 n0_1_10 0 50k
Rx0_2_0 n0_2_0 n1_2_0 1k
Ry0_2_0 n0_2_0 n0_3_0 1k
Rz0_2_0 n0_2_0 n0_2_1 1k
Rg0_2_0 n0_2_0 0 50k
Rx0_2_1 n0_2_1 n1_2_1 1k
Ry0_2_1 n0_2_1 n0_3_1 1k
Rz0_2_1 n0_2_1 n0_2_2 1k
Rg0_2_1 n0_2_1 0 50k
Rx0_2_2 n0_2_2 n1_2_2 1k
Ry0_2_2 n0_2_2 n0_3_2 1k
Rz0_2_2 n0_2_2 n0_2_3 1k
Rg0_2_2 n0_2_2 0 50k
Rx0_2_3 n0_2_3 n1_2_3 1k
Ry0_2_3 n0_2_3 n0_3_3 1k
Rz0_2_3 n0_2_3 n0_2_4 1k
Rg0_2_3 n0_2_3 0 50k
Rx0_2_4 n0_2_4 n1_2_4 1k
Ry0_2_4 n0_2_4 n0_3_4 1k
Rz0_2_4 n0_2_4 n0_2_5 1k
Rg0_2_4 n0_2_4 0 50k
Rx0_2_5 n0_2_5 n1_2_5 1k
Ry0_2_5 n0_2_5 n0_3_5 1k
Rz0_2_5 n0_2_5 n0_2_6 1k
Rg0_2_5 n0_2_5 0 50k
Rx0_2_6 n0_2_6 n1_2_6 1k
Ry0_2_6 n0_2_6 n0_3_6 1k
Rz0_2_6 n0_2_6 n0_2_7 1k
Rg0_2_6 n0_2_6 0 50k
Rx0_2_7 n0_2_7 n1_2_7 1k
Ry0_2_7 n0_2_7 n0_3_7 1k
Rz0_2_7 n0_2_7 n0_2_8 1k
Rg0_2_7 n0_2_7 0 50k
Rx0_2_8 n0_2_8 n1_2_8 1k
Ry0_2_8 n0_2_8 n0_3_8 1k
Rz0_2_8 n0_2_8 n0_2_9 1k
Rg0_2_8 n0_2_8 0 50k
Rx0_2_9 n0_2_9 n1_2_9 1k
Ry0_2_9 n0_2_9 n0_3_9 1k
Rz0_2_9 n0_2_9 n0_2_10 1k
Rg0_2_9 n0_2_9 0 50k
Rx0_2_10 n0_2_10 n1_2_10 1k
Ry0_2_10 n0_2_10 n0_3_10 1k
Rg0_2_10 n0_2_10 0 50k
Rx0_3_0 n0_3_0 n1_3_0 1k
Ry0_3_0 n0_3_0 n0_4_0 1k
Rz0_3_0 n0_3_0 n0_3_1 1k
Rg0_3_0 n0_3_0 0 50k
Rx0_3_1 n0_3_1 n1_3_1 1k
Ry0_3_1 n0_3_1 n0_4_1 1k
Rz0_3_1 n0_3_1 n0_3_2 1k
Rg0_3_1 n0_3_1 0 50k
Rx0_3_2 n0_3_2 n1_3_2 1k
Ry0_3_2 n0_3_2 n0_4_2 1k
Rz0_3_2 n0_3_2 n0_3_3 1k
Rg0_3_2 n0_3_2 0 50k
Rx0_3_3 n0_3_3 n1_3_3 1k
Ry0_3_3 n0_3_3 n0_4_3 1k
Rz0_3_3 n0_3_3 n0_3_4 1k
Rg0_3_3 n0_3_3 0 50k
Rx0_3_4 n0_3_4 n1_3_4 1k
Ry0_3_4 n0_3_4 n0_4_4 1k
Rz0_3_4 n0_3_4 n0_3_5 1k
Rg0_3_4 n0_3_4 0 50k
Rx0_3_5 n0_3_5 n1_3_5 1k
Ry0_3_5 n0_3_5 n0_4_5 1k
Rz0_3_5 n0_3_5 n0_3_6 1k
Rg0_3_5 n0_3_5 0 50k
Rx0_3_6 n0_3_6 n1_3_6 1k
Ry0_3_6 n0_3_6 n0_4_6 1k
Rz0_3_6 n0_3_6 n0_3_7 1k
Rg0_3_6 n0_3_6 0 50k
Rx0_3_7 n0_3_7 n1_3_7 1k
Ry0_3_7 n0_3_7 n0_4_7 1k
Rz0_3_7 n0_3_7 n0_3_8 1k
Rg0_3_7 n0_3_7 0 50k
Rx0_3_8 n0_3_8 n1_3_8 1k
Ry0_3_8 n0_3_8 n0_4_8 1k
Rz0_3_8 n0_3_8 n0_3_9 1k
Rg0_3_8 n0_3_8 0 50k
Rx0_3_9 n0_3_9 n1_3_9 1k
Ry0_3_9 n0_3_9 n0_4_9 1k
Rz0_3_9 n0_3_9 n0_3_10 1k
Rg0_3_9 n0_3_9 0 50k
Rx0_3_10 n0_3_10 n1_3_10 1k
Ry0_3_10 n0_3_10 n0_4_10 1k
Rg0_3_10 n0_3_10 0 50k
Rx0_4_0 n0_4_0 n1_4_0 1k
Ry0_4_0 n0_4_0 n0_5_0 1k
Rz0_4_0 n0_4_0 n0_4_1 1k
Rg0_4_0 n0_4_0 0 50k
Rx0_4_1 n0_4_1 n1_4_1 1k
Ry0_4_1 n0_4_1 n0_5_1 1k
Rz0_4_1 n0_4_1 n0_4_2 1k
Rg0_4_1 n0_4_1 0 50k
Rx0_4_2 n0_4_2 n1_4_2 1k
Ry0_4_2 n0_4_2 n0_5_2 1k
Rz0_4_2 n0_4_2 n0_4_3 1k
Rg0_4_2 n0_4_2 0 50k
Rx0_4_3 n0_4_3 n1_4_3 1k
Ry0_4_3 n0_4_3 n0_5_3 1k
Rz0_4_3 n0_4_3 n0_4_4 1k
Rg0_4_3 n0_4_3 0 50k
Rx0_4_4 n0_4_4 n1_4_4 1k
Ry0_4_4 n0_4_4 n0_5_4 1k
Rz0_4_4 n0_4_4 n0_4_5 1k
Rg0_4_4 n0_4_4 0 50k
Rx0_4_5 n0_4_5 n1_4_5 1k
Ry0_4_5 n0_4_5 n0_5_5 1k
Rz0_4_5 n0_4_5 n0_4_6 1k
Rg0_4_5 n0_4_5 0 50k
Rx0_4_6 n0_4_6 n1_4_6 1k
Ry0_4_6 n0_4_6 n0_5_6 1k
Rz0_4_6 n0_4_6 n0_4_7 1k
Rg0_4_6 n0_4_6 0 50k
Rx0_4_7 n0_4_7 n1_4_7 1k
Ry0_4_7 n0_4_7 n0_5_7 1k
Rz0_4_7 n0_4_7 n0_4_8 1k
Rg0_4_7 n0_4_7 0 50k
Rx0_4_8 n0_4_8 n1_4_8 1k
Ry0_4_8 n0_4_8 n0_5_8 1k
Rz0_4_8 n0_4_8 n0_4_9 1k
Rg0_4_8 n0_4_8 0 50k
Rx0_4_9 n0_4_9 n1_4_9 1k
Ry0_4_9 n0_4_9 n0_5_9 1k
Rz0_4_9 n0_4_9 n0_4_10 1k
Rg0_4_9 n0_4_9 0 50k
Rx0_4_10 n0_4_10 n1_4_10 1k
Ry0_4_10 n0_4_10 n0_5_10 1k
Rg0_4_10 n0_4_10 0 50k
Rx0_5_0 n0_5_0 n1_5_0 1k
Ry0_5_0 n0_5_0 n0_6_0 1k
Rz0_5_0 n0_5_0 n0_5_1 1k
Rg0_5_0 n0_5_0 0 50k
Rx0_5_1 n0_5_1 n1_5_1 1k
Ry0_5_1 n0_5_1 n0_6_1 1k
Rz0_5_1 n0_5_1 n0_5_2 1k
Rg0_5_1 n0_5_1 0 50k
Rx0_5_2 n0_5_2 n1_5_2 1k
Ry0_5_2 n0_5_2 n0_6_2 1k
Rz0_5_2 n0_5_2 n0_5_3 1k
Rg0_5_2 n0_5_2 0 50k
Rx0_5_3 n0_5_3 n1_5_3 1k
Ry0_5_3 n0_5_3 n0_6_3 1k
Rz0_5_3 n0_5_3 n0_5_4 1k
Rg0_5_3 n0_5_3 0 50k
Rx0_5_4 n0_5_4 n1_5_4 1k
Ry0_5_4 n0_5_4 n0_6_4 1k
Rz0_5_4 n0_5_4 n0_5_5 1k
Rg0_5_4 n0_5_4 0 50k
Rx0_5_5 n0_5_5 n1_5_5 1k
Ry0_5_5 n0_5_5 n0_6_5 1k
Rz0_5_5 n0_5_5 n0_5_6 1k
Rg0_5_5 n0_5_5 0 50k
Rx0_5_6 n0_5_6 n1_5_6 1k
Ry0_5_6 n0_5_6 n0_6_6 1k
Rz0_5_6 n0_5_6 n0_5_7 1k
Rg0_5_6 n0_5_6 0 50k
Rx0_5_7 n0_5_7 n1_5_7 1k
Ry0_5_7 n0_5_7 n0_6_7 1k
Rz0_5_7 n0_5_7 n0_5_8 1k
Rg0_5_7 n0_5_7 0 50k
Rx0_5_8 n0_5_8 n1_5_8 1k
Ry0_5_8 n0_5_8 n0_6_8 1k
Rz0_5_8 n0_5_8 n0_5_9 1k
Rg0_5_8 n0_5_8 0 50k
Rx0_5_9 n0_5_9 n1_5_9 1k
Ry0_5_9 n0_5_9 n0_6_9 1k
Rz0_5_9 n0_5_9 n0_5_10 1k
Rg0_5_9 n0_5_9 0 50k
Rx0_5_10 n0_5_10 n1_5_10 1k
Ry0_5_10 n0_5_10 n0_6_10 1k
Rg0_5_10 n0_5_10 0 50k
Rx0_6_0 n0_6_0 n1_6_0 1k
Ry0_6_0 n0_6_0 n0_7_0 1k
Rz0_6_0 n0_6_0 n0_6_1 1k
Rg0_6_0 n0_6_0 0 50k
Rx0_6_1 n0_6_1 n1_6_1 1k
Ry0_6_1 n0_6_1 n0_7_1 1k
Rz0_6_1 n0_6_1 n0_6_2 1k
Rg0_6_1 n0_6_1 0 50k
Rx0_6_2 n0_6_2 n1_6_2 1k
Ry0_6_2 n0_6_2 n0_7_2 1k
Rz0_6_2 n0_6_2 n0_6_3 1k
Rg0_6_2 n0_6_2 0 50k
Rx0_6_3 n0_6_3 n1_6_3 1k
Ry0_6_3 n0_6_3 n0_7_3 1k
Rz0_6_3 n0_6_3 n0_6_4 1k
Rg0_6_3 n0_6_3 0 50k
Rx0_6_4 n0_6_4 n1_6_4 1k
Ry0_6_4 n0_6_4 n0_7_4 1k
Rz0_6_4 n0_6_4 n0_6_5 1k
Rg0_6_4 n0_6_4 0 50k
Rx0_6_5 n0_6_5 n1_6_5 1k
Ry0_6_5 n0_6_5 n0_7_5 1k
Rz0_6_5 n0_6_5 n0_6_6 1k
Rg0_6_5 n0_6_5 0 50k
Rx0_6_6 n0_6_6 n1_6_6 1k
Ry0_6_6 n0_6_6 n0_7_6 1k
Rz0_6_6 n0_6_6 n0_6_7 1k
Rg0_6_6 n0_6_6 0 50k
Rx0_6_7 n0_6_7 n1_6_7 1k
Ry0_6_7 n0_6_7 n0_7_7 1k
Rz0_6_7 n0_6_7 n0_6_8 1k
Rg0_6_7 n0_6_7 0 50k
Rx0_6_8 n0_6_8 n1_6_8 1k
Ry0_6_8 n0_6_8 n0_7_8 1k
Rz0_6_8 n0_6_8 n0_6_9 1k
Rg0_6_8 n0_6_8 0 50k
Rx0_6_9 n0_6_9 n1_6_9 1k
Ry0_6_9 n0_6_9 n0_7_9 1k
Rz0_6_9 n0_6_9 n0_6_10 1k
Rg0_6_9 n0_6_9 0 50k
Rx0_6_10 n0_6_10 n1_6_10 1k
Ry0_6_10 n0_6_10 n0_7_10 1k
Rg0_6_10 n0_6_10 0 50k
Rx0_7_0 n0_7_0 n1_7_0 1k
Ry0_7_0 n0_7_0 n0_8_0 1k
Rz0_7_0 n0_7_0 n0_7_1 1k
Rg0_7_0 n0_7_0 0 50k
Rx0_7_1 n0_7_1 n1_7_1 1k
Ry0_7_1 n0_7_1 n0_8_1 1k
Rz0_7_1 n0_7_1 n0_7_2 1k
Rg0_7_1 n0_7_1 0 50k
Rx0_7_2 n0_7_2 n1_7_2 1k
Ry0_7_2 n0_7_2 n0_8_2 1k
Rz0_7_2 n0_7_2 n0_7_3 1k
Rg0_7_2 n0_7_2 0 50k
Rx0_7_3 n0_7_3 n1_7_3 1k
Ry0_7_3 n0_7_3 n0_8_3 1k
Rz0_7_3 n0_7_3 n0_7_4 1k
Rg0_7_3 n0_7_3 0 50k
Rx0_7_4 n0_7_4 n1_7_4 1k
Ry0_7_4 n0_7_4 n0_8_4 1k
Rz0_7_4 n0_7_4 n0_7_5 1k
Rg0_7_4 n0_7_4 0 50k
Rx0_7_5 n0_7_5 n1_7_5 1k
Ry0_7_5 n0_7_5 n0_8_5 1k
Rz0_7_5 n0_7_5 n0_7_6 1k
Rg0_7_5 n0_7_5 0 50k
Rx0_7_6 n0_7_6 n1_7_6 1k
Ry0_7_6 n0_7_6 n0_8_6 1k
Rz0_7_6 n0_7_6 n0_7_7 1k
Rg0_7_6 n0_7_6 0 50k
Rx0_7_7 n0_7_7 n1_7_7 1k
Ry0_7_7 n0_7_7 n0_8_7 1k
Rz0_7_7 n0_7_7 n0_7_8 1k
Rg0_7_7 n0_7_7 0 50k
Rx0_7_8 n0_7_8 n1_7_8 1k
Ry0_7_8 n0_7_8 n0_8_8 1k
Rz0_7_8 n0_7_8 n0_7_9 1k
Rg0_7_8 n0_7_8 0 50k
Rx0_7_9 n0_7_9 n1_7_9 1k
Ry0_7_9 n0_7_9 n0_8_9 1k
Rz0_7_9 n0_7_9 n0_7_10 1k
Rg0_7_9 n0_7_9 0 50k
Rx0_7_10 n0_7_10 n1_7_10 1k
Ry0_7_10 n0_7_10 n0_8_10 1k
Rg0_7_10 n0_7_10 0 50k
Rx0_8_0 n0_8_0 n1_8_0 1k
Ry0_8_0 n0_8_0 n0_9_0 1k
Rz0_8_0 n0_8_0 n0_8_1 1k
Rg0_8_0 n0_8_0 0 50k
Rx0_8_1 n0_8_1 n1_8_1 1k
Ry0_8_1 n0_8_1 n0_9_1 1k
Rz0_8_1 n0_8_1 n0_8_2 1k
Rg0_8_1 n0_8_1 0 50k
Rx0_8_2 n0_8_2 n1_8_2 1k
Ry0_8_2 n0_8_2 n0_9_2 1k
Rz0_8_2 n0_8_2 n0_8_3 1k
Rg0_8_2 n0_8_2 0 50k
Rx0_8_3 n0_8_3 n1_8_3 1k
Ry0_8_3 n0_8_3 n0_9_3 1k
Rz0_8_3 n0_8_3 n0_8_4 1k
Rg0_8_3 n0_8_3 0 50k
Rx0_8_4 n0_8_4 n1_8_4 1k
Ry0_8_4 n0_8_4 n0_9_4 1k
Rz0_8_4 n0_8_4 n0_8_5 1k
Rg0_8_4 n0_8_4 0 50k
Rx0_8_5 n0_8_5 n1_8_5 1k
Ry0_8_5 n0_8_5 n0_9_5 1k
Rz0_8_5 n0_8_5 n0_8_6 1k
Rg0_8_5 n0_8_5 0 50k
Rx0_8_6 n0_8_6 n1_8_6 1k
Ry0_8_6 n0_8_6 n0_9_6 1k
Rz0_8_6 n0_8_6 n0_8_7 1k
Rg0_8_6 n0_8_6 0 50k
Rx0_8_7 n0_8_7 n1_8_7 1k
Ry0_8_7 n0_8_7 n0_9_7 1k
Rz0_8_7 n0_8_7 n0_8_8 1k
Rg0_8_7 n0_8_7 0 50k
Rx0_8_8 n0_8_8 n1_8_8 1k
Ry0_8_8 n0_8_8 n0_9_8 1k
Rz0_8_8 n0_8_8 n0_8_9 1k
Rg0_8_8 n0_8_8 0 50k
Rx0_8_9 n0_8_9 n1_8_9 1k
Ry0_8_9 n0_8_9 n0_9_9 1k
Rz0_8_9 n0_8_9 n0_8_10 1k
Rg0_8_9 n0_8_9 0 50k
Rx0_8_10 n0_8_10 n1_8_10 1k
Ry0_8_10 n0_8_10 n0_9_10 1k
Rg0_8_10 n0_8_10 0 50k
Rx0_9_0 n0_9_0 n1_9_0 1k
Ry0_9_0 n0_9_0 n0_10_0 1k
Rz0_9_0 n0_9_0 n0_9_1 1k
Rg0_9_0 n0_9_0 0 50k
Rx0_9_1 n0_9_1 n1_9_1 1k
Ry0_9_1 n0_9_1 n0_10_1 1k
Rz0_9_1 n0_9_1 n0_9_2 1k
Rg0_9_1 n0_9_1 0 50k
Rx0_9_2 n0_9_2 n1_9_2 1k
Ry0_9_2 n0_9_2 n0_10_2 1k
Rz0_9_2 n0_9_2 n0_9_3 1k
Rg0_9_2 n0_9_2 0 50k
Rx0_9_3 n0_9_3 n1_9_3 1k
Ry0_9_3 n0_9_3 n0_10_3 1k
Rz0_9_3 n0_9_3 n0_9_4 1k
Rg0_9_3 n0_9_3 0 50k
Rx0_9_4 n0_9_4 n1_9_4 1k
Ry0_9_4 n0_9_4 n0_10_4 1k
Rz0_9_4 n0_9_4 n0_9_5 1k
Rg0_9_4 n0_9_4 0 50k
Rx0_9_5 n0_9_5 n1_9_5 1k
Ry0_9_5 n0_9_5 n0_10_5 1k
Rz0_9_5 n0_9_5 n0_9_6 1k
Rg0_9_5 n0_9_5 0 50k
Rx0_9_6 n0_9_6 n1_9_6 1k
Ry0_9_6 n0_9_6 n0_10_6 1k
Rz0_9_6 n0_9_6 n0_9_7 1k
Rg0_9_6 n0_9_6 0 50k
Rx0_9_7 n0_9_7 n1_9_7 1k
Ry0_9_7 n0_9_7 n0_10_7 1k
Rz0_9_7 n0_9_7 n0_9_8 1k
Rg0_9_7 n0_9_7 0 50k
Rx0_9_8 n0_9_8 n1_9_8 1k
Ry0_9_8 n0_9_8 n0_10_8 1k
Rz0_9_8 n0_9_8 n0_9_9 1k
Rg0_9_8 n0_9_8 0 50k
Rx0_9_9 n0_9_9 n1_9_9 1k
Ry0_9_9 n0_9_9 n0_10_9 1k
Rz0_9_9 n0_9_9 n0_9_10 1k
Rg0_9_9 n0_9_9 0 50k
Rx0_9_10 n0_9_10 n1_9_10 1k
Ry0_9_10 n0_9_10 n0_10_10 1k
Rg0_9_10 n0_9_10 0 50k
Rx0_10_0 n0_10_0 n1_10_0 1k
Rz0_10_0 n0_10_0 n0_10_1 1k
Rg0_10_0 n0_10_0 0 50k
Rx0_10_1 n0_10_1 n1_10_1 1k
Rz0_10_1 n0_10_1 n0_10_2 1k
Rg0_10_1 n0_10_1 0 50k
Rx0_10_2 n0_10_2 n1_10_2 1k
Rz0_10_2 n0_10_2 n0_10_3 1k
Rg0_10_2 n0_10_2 0 50k
Rx0_10_3 n0_10_3 n1_10_3 1k
Rz0_10_3 n0_10_3 n0_10_4 1k
Rg0_10_3 n0_10_3 0 50k
Rx0_10_4 n0_10_4 n1_10_4 1k
Rz0_10_4 n0_10_4 n0_10_5 1k
Rg0_10_4 n0_10_4 0 50k
Rx0_10_5 n0_10_5 n1_10_5 1k
Rz0_10_5 n0_10_5 n0_10_6 1k
Rg0_10_5 n0_10_5 0 50k
Rx0_10_6 n0_10_6 n1_10_6 1k
Rz0_10_6 n0_10_6 n0_10_7 1k
Rg0_10_6 n0_10_6 0 50k
Rx0_10_7 n0_10_7 n1_10_7 1k
Rz0_10_7 n0_10_7 n0_10_8 1k
Rg0_10_7 n0_10_7 0 50k
Rx0_10_8 n0_10_8 n1_10_8 1k
Rz0_10_8 n0_10_8 n0_10_9 1k
Rg0_10_8 n0_10_8 0 50k
Rx0_10_9 n0_10_9 n1_10_9 1k
Rz0_10_9 n0_10_9 n0_10_10 1k
Rg0_10_9 n0_10_9 0 50k
Rx0_10_10 n0_10_10 n1_10_10 1k
Rg0_10_10 n0_10_10 0 50k
Rx1_0_0 n1_0_0 n2_0_0 1k
Ry1_0_0 n1_0_0 n1_1_0 1k
Rz1_0_0 n1_0_0 n1_0_1 1k
Rg1_0_0 n1_0_0 0 50k
Rx1_0_1 n1_0_1 n2_0_1 1k
Ry1_0_1 n1_0_1 n1_1_1 1k
Rz1_0_1 n1_0_1 n1_0_2 1k
Rg1_0_1 n1_0_1 0 50k
Rx1_0_2 n1_0_2 n2_0_2 1k
Ry1_0_2 n1_0_2 n1_1_2 1k
Rz1_0_2 n1_0_2 n1_0_3 1k
Rg1_0_2 n1_0_2 0 50k
Rx1_0_3 n1_0_3 n2_0_3 1k
Ry1_0_3 n1_0_3 n1_1_3 1k
Rz1_0_3 n1_0_3 n1_0_4 1k
Rg1_0_3 n1_0_3 0 50k
Rx1_0_4 n1_0_4 n2_0_4 1k
Ry1_0_4 n1_0_4 n1_1_4 1k
Rz1_0_4 n1_0_4 n1_0_5 1k
Rg1_0_4 n1_0_4 0 50k
Rx1_0_5 n1_0_5 n2_0_5 1k
Ry1_0_5 n1_0_5 n1_1_5 1k
Rz1_0_5 n1_0_5 n1_0_6 1k
Rg1_0_5 n1_0_5 0 50k
Rx1_0_6 n1_0_6 n2_0_6 1k
Ry1_0_6 n1_0_6 n1_1_6 1k
Rz1_0_6 n1_0_6 n1_0_7 1k
Rg1_0_6 n1_0_6 0 50k
Rx1_0_7 n1_0_7 n2_0_7 1k
Ry1_0_7 n1_0_7 n1_1_7 1k
Rz1_0_7 n1_0_7 n1_0_8 1k
Rg1_0_7 n1_0_7 0 50k
Rx1_0_8 n1_0_8 n2_0_8 1k
Ry1_0_8 n1_0_8 n1_1_8 1k
Rz1_0_8 n1_0_8 n1_0_9 1k
Rg1_0_8 n1_0_8 0 50k
Rx1_0_9 n1_0_9 n2_0_9 1k
Ry1_0_9 n1_0_9 n1_1_9 1k
Rz1_0_9 n1_0_9 n1_0_10 1k
Rg1_0_9 n1_0_9 0 50k
Rx1_0_10 n1_0_10 n2_0_10 1k
Ry1_0_10 n1_0_10 n1_1_10 1k
Rg1_0_10 n1_0_10 0 50k
Rx1_1_0 n1_1_0 n2_1_0 1k
Ry1_1_0 n1_1_0 n1_2_0 1k
Rz1_1_0 n1_1_0 n1_1_1 1k
Rg1_1_0 n1_1_0 0 50k
Rx1_1_1 n1_1_1 n2_1_1 1k
Ry1_1_1 n1_1_1 n1_2_1 1k
Rz1_1_1 n1_1_1 n1_1_2 1k
Rg1_1_1 n1_1_1 0 50k
Rx1_1_2 n1_1_2 n2_1_2 1k
Ry1_1_2 n1_1_2 n1_2_2 1k
Rz1_1_2 n1_1_2 n1_1_3 1k
Rg1_1_2 n1_1_2 0 50k
Rx1_1_3 n1_1_3 n2_1_3 1k
Ry1_1_3 n1_1_3 n1_2_3 1k
Rz1_1_3 n1_1_3 n1_1_4 1k
Rg1_1_3 n1_1_3 0 50k
Rx1_1_4 n1_1_4 n2_1_4 1k
Ry1_1_4 n1_1_4 n1_2_4 1k
Rz1_1_4 n1_1_4 n1_1_5 1k
Rg1_1_4 n1_1_4 0 50k
Rx1_1_5 n1_1_5 n2_1_5 1k
Ry1_1_5 n1_1_5 n1_2_5 1k
Rz1_1_5 n1_1_5 n1_1_6 1k
Rg1_1_5 n1_1_5 0 50k
Rx1_1_6 n1_1_6 n2_1_6 1k
Ry1_1_6 n1_1_6 n1_2_6 1k
Rz1_1_6 n1_1_6 n1_1_7 1k
Rg1_1_6 n1_1_6 0 50k
Rx1_1_7 n1_1_7 n2_1_7 1k
Ry1_1_7 n1_1_7 n1_2_7 1k
Rz1_1_7 n1_1_7 n1_1_8 1k
Rg1_1_7 n1_1_7 0 50k
Rx1_1_8 n1_1_8 n2_1_8 1k
Ry1_1_8 n1_1_8 n1_2_8 1k
Rz1_1_8 n1_1_8 n1_1_9 1k
Rg1_1_8 n1_1_8 0 50k
Rx1_1_9 n1_1_9 n2_1_9 1k
Ry1_1_9 n1_1_9 n1_2_9 1k
Rz1_1_9 n1_1_9 n1_1_10 1k
Rg1_1_9 n1_1_9 0 50k
Rx1_1_10 n1_1_10 n2_1_10 1k
Ry1_1_10 n1_1_10 n1_2_10 1k
Rg1_1_10 n1_1_10 0 50k
Rx1_2_0 n1_2_0 n2_2_0 1k
Ry1_2_0 n1_2_0 n1_3_0 1k
Rz1_2_0 n1_2_0 n1_2_1 1k
Rg1_2_0 n1_2_0 0 50k
Rx1_2_1 n1_2_1 n2_2_1 1k
Ry1_2_1 n1_2_1 n1_3_1 1k
Rz1_2_1 n1_2_1 n1_2_2 1k
Rg1_2_1 n1_2_1 0 50k
Rx1_2_2 n1_2_2 n2_2_2 1k
Ry1_2_2 n1_2_2 n1_3_2 1k
Rz1_2_2 n1_2_2 n1_2_3 1k
Rg1_2_2 n1_2_2 0 50k
Rx1_2_3 n1_2_3 n2_2_3 1k
Ry1_2_3 n1_2_3 n1_3_3 1k
Rz1_2_3 n1_2_3 n1_2_4 1k
Rg1_2_3 n1_2_3 0 50k
Rx1_2_4 n1_2_4 n2_2_4 1k
Ry1_2_4 n1_2_4 n1_3_4 1k
Rz1_2_4 n1_2_4 n1_2_5 1k
Rg1_2_4 n1_2_4 0 50k
Rx1_2_5 n1_2_5 n2_2_5 1k
Ry1_2_5 n1_2_5 n1_3_5 1k
Rz1_2_5 n1_2_5 n1_2_6 1k
Rg1_2_5 n1_2_5 0 50k
Rx1_2_6 n1_2_6 n2_2_6 1k
Ry1_2_6 n1_2_6 n1_3_6 1k
Rz1_2_6 n1_2_6 n1_2_7 1k
Rg1_2_6 n1_2_6 0 50k
Rx1_2_7 n1_2_7 n2_2_7 1k
Ry1_2_7 n1_2_7 n1_3_7 1k
Rz1_2_7 n1_2_7 n1_2_8 1k
Rg1_2_7 n1_2_7 0 50k
Rx1_2_8 n1_2_8 n2_2_8 1k
Ry1_2_8 n1_2_8 n1_3_8 1k
Rz1_2_8 n1_2_8 n1_2_9 1k
Rg1_2_8 n1_2_8 0 50k
Rx1_2_9 n1_2_9 n2_2_9 1k
Ry1_2_9 n1_2_9 n1_3_9 1k
Rz1_2_9 n1_2_9 n1_2_10 1k
Rg1_2_9 n1_2_9 0 50k
Rx1_2_10 n1_2_10 n2_2_10 1k
Ry1_2_10 n1_2_10 n1_3_10 1k
Rg1_2_10 n1_2_10 0 50k
Rx1_3_0 n1_3_0 n2_3_0 1k
Ry1_3_0 n1_3_0 n1_4_0 1k
Rz1_3_0 n1_3_0 n1_3_1 1k
Rg1_3_0 n1_3_0 0 50k
Rx1_3_1 n1_3_1 n2_3_1 1k
Ry1_3_1 n1_3_1 n1_4_1 1k
Rz1_3_1 n1_3_1 n1_3_2 1k
Rg1_3_1 n1_3_1 0 50k
Rx1_3_2 n1_3_2 n2_3_2 1k
Ry1_3_2 n1_3_2 n1_4_2 1k
Rz1_3_2 n1_3_2 n1_3_3 1k
Rg1_3_2 n1_3_2 0 50k
Rx1_3_3 n1_3_3 n2_3_3 1k
Ry1_3_3 n1_3_3 n1_4_3 1k
Rz1_3_3 n1_3_3 n1_3_4 1k
Rg1_3_3 n1_3_3 0 50k
Rx1_3_4 n1_3_4 n2_3_4 1k
Ry1_3_4 n1_3_4 n1_4_4 1k
Rz1_3_4 n1_3_4 n1_3_5 1k
Rg1_3_4 n1_3_4 0 50k
Rx1_3_5 n1_3_5 n2_3_5 1k
Ry1_3_5 n1_3_5 n1_4_5 1k
Rz1_3_5 n1_3_5 n1_3_6 1k
Rg1_3_5 n1_3_5 0 50k
Rx1_3_6 n1_3_6 n2_3_6 1k
Ry1_3_6 n1_3_6 n1_4_6 1k
Rz1_3_6 n1_3_6 n1_3_7 1k
Rg1_3_6 n1_3_6 0 50k
Rx1_3_7 n1_3_7 n2_3_7 1k
Ry1_3_7 n1_3_7 n1_4_7 1k
Rz1_3_7 n1_3_7 n1_3_8 1k
Rg1_3_7 n1_3_7 0 50k
Rx1_3_8 n1_3_8 n2_3_8 1k
Ry1_3_8 n1_3_8 n1_4_8 1k
Rz1_3_8 n1_3_8 n1_3_9 1k
Rg1_3_8 n1_3_8 0 50k
Rx1_3_9 n1_3_9 n2_3_9 1k
Ry1_3_9 n1_3_9 n1_4_9 1k
Rz1_3_9 n1_3_9 n1_3_10 1k
Rg1_3_9 n1_3_9 0 50k
Rx1_3_10 n1_3_10 n2_3_10 1k
Ry1_3_10 n1_3_10 n1_4_10 1k
Rg1_3_10 n1_3_10 0 50k
Rx1_4_0 n1_4_0 n2_4_0 1k
Ry1_4_0 n1_4_0 n1_5_0 1k
Rz1_4_0 n1_4_0 n1_4_1 1k
Rg1_4_0 n1_4_0 0 50k
Rx1_4_1 n1_4_1 n2_4_1 1k
Ry1_4_1 n1_4_1 n1_5_1 1k
Rz1_4_1 n1_4_1 n1_4_2 1k
Rg1_4_1 n1_4_1 0 50k
Rx1_4_2 n1_4_2 n2_4_2 1k
Ry1_4_2 n1_4_2 n1_5_2 1k
Rz1_4_2 n1_4_2 n1_4_3 1k
Rg1_4_2 n1_4_2 0 50k
Rx1_4_3 n1_4_3 n2_4_3 1k
Ry1_4_3 n1_4_3 n1_5_3 1k
Rz1_4_3 n1_4_3 n1_4_4 1k
Rg1_4_3 n1_4_3 0 50k
Rx1_4_4 n1_4_4 n2_4_4 1k
Ry1_4_4 n1_4_4 n1_5_4 1k
Rz1_4_4 n1_4_4 n1_4_5 1k
Rg1_4_4 n1_4_4 0 50k
Rx1_4_5 n1_4_5 n2_4_5 1k
Ry1_4_5 n1_4_5 n1_5_5 1k
Rz1_4_5 n1_4_5 n1_4_6 1k
Rg1_4_5 n1_4_5 0 50k
Rx1_4_6 n1_4_6 n2_4_6 1k
Ry1_4_6 n1_4_6 n1_5_6 1k
Rz1_4_6 n1_4_6 n1_4_7 1k
Rg1_4_6 n1_4_6 0 50k
Rx1_4_7 n1_4_7 n2_4_7 1k
Ry1_4_7 n1_4_7 n1_5_7 1k
Rz1_4_7 n1_4_7 n1_4_8 1k
Rg1_4_7 n1_4_7 0 50k
Rx1_4_8 n1_4_8 n2_4_8 1k
Ry1_4_8 n1_4_8 n1_5_8 1k
Rz1_4_8 n1_4_8 n1_4_9 1k
Rg1_4_8 n1_4_8 0 50k
Rx1_4_9 n1_4_9 n2_4_9 1k
Ry1_4_9 n1_4_9 n1_5_9 1k
Rz1_4_9 n1_4_9 n1_4_10 1k
Rg1_4_9 n1_4_9 0 50k
Rx1_4_10 n1_4_10 n2_4_10 1k
Ry1_4_10 n1_4_10 n1_5_10 1k
Rg1_4_10 n1_4_10 0 50k
Rx1_5_0 n1_5_0 n2_5_0 1k
Ry1_5_0 n1_5_0 n1_6_0 1k
Rz1_5_0 n1_5_0 n1_5_1 1k
Rg1_5_0 n1_5_0 0 50k
Rx1_5_1 n1_5_1 n2_5_1 1k
Ry1_5_1 n1_5_1 n1_6_1 1k
Rz1_5_1 n1_5_1 n1_5_2 1k
Rg1_5_1 n1_5_1 0 50k
Rx1_5_2 n1_5_2 n2_5_2 1k
Ry1_5_2 n1_5_2 n1_6_2 1k
Rz1_5_2 n1_5_2 n1_5_3 1k
Rg1_5_2 n1_5_2 0 50k
Rx1_5_3 n1_5_3 n2_5_3 1k
Ry1_5_3 n1_5_3 n1_6_3 1k
Rz1_5_3 n1_5_3 n1_5_4 1k
Rg1_5_3 n1_5_3 0 50k
Rx1_5_4 n1_5_4 n2_5_4 1k
Ry1_5_4 n1_5_4 n1_6_4 1k
Rz1_5_4 n1_5_4 n1_5_5 1k
Rg1_5_4 n1_5_4 0 50k
Rx1_5_5 n1_5_5 n2_5_5 1k
Ry1_5_5 n1_5_5 n1_6_5 1k
Rz1_5_5 n1_5_5 n1_5_6 1k
Rg1_5_5 n1_5_5 0 50k
Rx1_5_6 n1_5_6 n2_5_6 1k
Ry1_5_6 n1_5_6 n1_6_6 1k
Rz1_5_6 n1_5_6 n1_5_7 1k
Rg1_5_6 n1_5_6 0 50k
Rx1_5_7 n1_5_7 n2_5_7 1k
Ry1_5_7 n1_5_7 n1_6_7 1k
Rz1_5_7 n1_5_7 n1_5_8 1k
Rg1_5_7 n1_5_7 0 50k
Rx1_5_8 n1_5_8 n2_5_8 1k
Ry1_5_8 n1_5_8 n1_6_8 1k
Rz1_5_8 n1_5_8 n1_5_9 1k
Rg1_5_8 n1_5_8 0 50k
Rx1_5_9 n1_5_9 n2_5_9 1k
Ry1_5_9 n1_5_9 n1_6_9 1k
Rz1_5_9 n1_5_9 n1_5_10 1k
Rg1_5_9 n1_5_9 0 50k
Rx1_5_10 n1_5_10 n2_5_10 1k
Ry1_5_10 n1_5_10 n1_6_10 1k
Rg1_5_10 n1_5_10 0 50k
Rx1_6_0 n1_6_0 n2_6_0 1k
Ry1_6_0 n1_6_0 n1_7_0 1k
Rz1_6_0 n1_6_0 n1_6_1 1k
Rg1_6_0 n1_6_0 0 50k
Rx1_6_1 n1_6_1 n2_6_1 1k
Ry1_6_1 n1_6_1 n1_7_1 1k
Rz1_6_1 n1_6_1 n1_6_2 1k
Rg1_6_1 n1_6_1 0 50k
Rx1_6_2 n1_6_2 n2_6_2 1k
Ry1_6_2 n1_6_2 n1_7_2 1k
Rz1_6_2 n1_6_2 n1_6_3 1k
Rg1_6_2 n1_6_2 0 50k
Rx1_6_3 n1_6_3 n2_6_3 1k
Ry1_6_3 n1_6_3 n1_7_3 1k
Rz1_6_3 n1_6_3 n1_6_4 1k
Rg1_6_3 n1_6_3 0 50k
Rx1_6_4 n1_6_4 n2_6_4 1k
Ry1_6_4 n1_6_4 n1_7_4 1k
Rz1_6_4 n1_6_4 n1_6_5 1k
Rg1_6_4 n1_6_4 0 50k
Rx1_6_5 n1_6_5 n2_6_5 1k
Ry1_6_5 n1_6_5 n1_7_5 1k
Rz1_6_5 n1_6_5 n1_6_6 1k
Rg1_6_5 n1_6_5 0 50k
Rx1_6_6 n1_6_6 n2_6_6 1k
Ry1_6_6 n1_6_6 n1_7_6 1k
Rz1_6_6 n1_6_6 n1_6_7 1k
Rg1_6_6 n1_6_6 0 50k
Rx1_6_7 n1_6_7 n2_6_7 1k
Ry1_6_7 n1_6_7 n1_7_7 1k
Rz1_6_7 n1_6_7 n1_6_8 1k
Rg1_6_7 n1_6_7 0 50k
Rx1_6_8 n1_6_8 n2_6_8 1k
Ry1_6_8 n1_6_8 n1_7_8 1k
Rz1_6_8 n1_6_8 n1_6_9 1k
Rg1_6_8 n1_6_8 0 50k
Rx1_6_9 n1_6_9 n2_6_9 1k
Ry1_6_9 n1_6_9 n1_7_9 1k
Rz1_6_9 n1_6_9 n1_6_10 1k
Rg1_6_9 n1_6_9 0 50k
Rx1_6_10 n1_6_10 n2_6_10 1k
Ry1_6_10 n1_6_10 n1_7_10 1k
Rg1_6_10 n1_6_10 0 50k
Rx1_7_0 n1_7_0 n2_7_0 1k
Ry1_7_0 n1_7_0 n1_8_0 1k
Rz1_7_0 n1_7_0 n1_7_1 1k
Rg1_7_0 n1_7_0 0 50k
Rx1_7_1 n1_7_1 n2_7_1 1k
Ry1_7_1 n1_7_1 n1_8_1 1k
Rz1_7_1 n1_7_1 n1_7_2 1k
Rg1_7_1 n1_7_1 0 50k
Rx1_7_2 n1_7_2 n2_7_2 1k
Ry1_7_2 n1_7_2 n1_8_2 1k
Rz1_7_2 n1_7_2 n1_7_3 1k
Rg1_7_2 n1_7_2 0 50k
Rx1_7_3 n1_7_3 n2_7_3 1k
Ry1_7_3 n1_7_3 n1_8_3 1k
Rz1_7_3 n1_7_3 n1_7_4 1k
Rg1_7_3 n1_7_3 0 50k
Rx1_7_4 n1_7_4 n2_7_4 1k
Ry1_7_4 n1_7_4 n1_8_4 1k
Rz1_7_4 n1_7_4 n1_7_5 1k
Rg1_7_4 n1_7_4 0 50k
Rx1_7_5 n1_7_5 n2_7_5 1k
Ry1_7_5 n1_7_5 n1_8_5 1k
Rz1_7_5 n1_7_5 n1_7_6 1k
Rg1_7_5 n1_7_5 0 50k
Rx1_7_6 n1_7_6 n2_7_6 1k
Ry1_7_6 n1_7_6 n1_8_6 1k
Rz1_7_6 n1_7_6 n1_7_7 1k
Rg1_7_6 n1_7_6 0 50k
Rx1_7_7 n1_7_7 n2_7_7 1k
Ry1_7_7 n1_7_7 n1_8_7 1k
Rz1_7_7 n1_7_7 n1_7_8 1k
Rg1_7_7 n1_7_7 0 50k
Rx1_7_8 n1_7_8 n2_7_8 1k
Ry1_7_8 n1_7_8 n1_8_8 1k
Rz1_7_8 n1_7_8 n1_7_9 1k
Rg1_7_8 n1_7_8 0 50k
Rx1_7_9 n1_7_9 n2_7_9 1k
Ry1_7_9 n1_7_9 n1_8_9 1k
Rz1_7_9 n1_7_9 n1_7_10 1k
Rg1_7_9 n1_7_9 0 50k
Rx1_7_10 n1_7_10 n2_7_10 1k
Ry1_7_10 n1_7_10 n1_8_10 1k
Rg1_7_10 n1_7_10 0 50k
Rx1_8_0 n1_8_0 n2_8_0 1k
Ry1_8_0 n1_8_0 n1_9_0 1k
Rz1_8_0 n1_8_0 n1_8_1 1k
Rg1_8_0 n1_8_0 0 50k
Rx1_8_1 n1_8_1 n2_8_1 1k
Ry1_8_1 n1_8_1 n1_9_1 1k
Rz1_8_1 n1_8_1 n1_8_2 1k
Rg1_8_1 n1_8_1 0 50k
Rx1_8_2 n1_8_2 n2_8_2 1k
Ry1_8_2 n1_8_2 n1_9_2 1k
Rz1_8_2 n1_8_2 n1_8_3 1k
Rg1_8_2 n1_8_2 0 50k
Rx1_8_3 n1_8_3 n2_8_3 1k
Ry1_8_3 n1_8_3 n1_9_3 1k
Rz1_8_3 n1_8_3 n1_8_4 1k
Rg1_8_3 n1_8_3 0 50k
Rx1_8_4 n1_8_4 n2_8_4 1k
Ry1_8_4 n1_8_4 n1_9_4 1k
Rz1_8_4 n1_8_4 n1_8_5 1k
Rg1_8_4 n1_8_4 0 50k
Rx1_8_5 n1_8_5 n2_8_5 1k
Ry1_8_5 n1_8_5 n1_9_5 1k
Rz1_8_5 n1_8_5 n1_8_6 1k
Rg1_8_5 n1_8_5 0 50k
Rx1_8_6 n1_8_6 n2_8_6 1k
Ry1_8_6 n1_8_6 n1_9_6 1k
Rz1_8_6 n1_8_6 n1_8_7 1k
Rg1_8_6 n1_8_6 0 50k
Rx1_8_7 n1_8_7 n2_8_7 1k
Ry1_8_7 n1_8_7 n1_9_7 1k
Rz1_8_7 n1_8_7 n1_8_8 1k
Rg1_8_7 n1_8_7 0 50k
Rx1_8_8 n1_8_8 n2_8_8 1k
Ry1_8_8 n1_8_8 n1_9_8 1k
Rz1_8_8 n1_8_8 n1_8_9 1k
Rg1_8_8 n1_8_8 0 50k
Rx1_8_9 n1_8_9 n2_8_9 1k
Ry1_8_9 n1_8_9 n1_9_9 1k
Rz1_8_9 n1_8_9 n1_8_10 1k
Rg1_8_9 n1_8_9 0 50k
Rx1_8_10 n1_8_10 n2_8_10 1k
Ry1_8_10 n1_8_10 n1_9_10 1k
Rg1_8_10 n1_8_10 0 50k
Rx1_9_0 n1_9_0 n2_9_0 1k
Ry1_9_0 n1_9_0 n1_10_0 1k
Rz1_9_0 n1_9_0 n1_9_1 1k
Rg1_9_0 n1_9_0 0 50k
Rx1_9_1 n1_9_1 n2_9_1 1k
Ry1_9_1 n1_9_1 n1_10_1 1k
Rz1_9_1 n1_9_1 n1_9_2 1k
Rg1_9_1 n1_9_1 0 50k
Rx1_9_2 n1_9_2 n2_9_2 1k
Ry1_9_2 n1_9_2 n1_10_2 1k
Rz1_9_2 n1_9_2 n1_9_3 1k
Rg1_9_2 n1_9_2 0 50k
Rx1_9_3 n1_9_3 n2_9_3 1k
Ry1_9_3 n1_9_3 n1_10_3 1k
Rz1_9_3 n1_9_3 n1_9_4 1k
Rg1_9_3 n1_9_3 0 50k
Rx1_9_4 n1_9_4 n2_9_4 1k
Ry1_9_4 n1_9_4 n1_10_4 1k
Rz1_9_4 n1_9_4 n1_9_5 1k
Rg1_9_4 n1_9_4 0 50k
Rx1_9_5 n1_9_5 n2_9_5 1k
Ry1_9_5 n1_9_5 n1_10_5 1k
Rz1_9_5 n1_9_5 n1_9_6 1k
Rg1_9_5 n1_9_5 0 50k
Rx1_9_6 n1_9_6 n2_9_6 1k
Ry1_9_6 n1_9_6 n1_10_6 1k
Rz1_9_6 n1_9_6 n1_9_7 1k
Rg1_9_6 n1_9_6 0 50k
Rx1_9_7 n1_9_7 n2_9_7 1k
Ry1_9_7 n1_9_7 n1_10_7 1k
Rz1_9_7 n1_9_7 n1_9_8 1k
Rg1_9_7 n1_9_7 0 50k
Rx1_9_8 n1_9_8 n2_9_8 1k
Ry1_9_8 n1_9_8 n1_10_8 1k
Rz1_9_8 n1_9_8 n1_9_9 1k
Rg1_9_8 n1_9_8 0 50k
Rx1_9_9 n1_9_9 n2_9_9 1k
Ry1_9_9 n1_9_9 n1_10_9 1k
Rz1_9_9 n1_9_9 n1_9_10 1k
Rg1_9_9 n1_9_9 0 50k
Rx1_9_10 n1_9_10 n2_9_10 1k
Ry1_9_10 n1_9_10 n1_10_10 1k
Rg1_9_10 n1_9_10 0 50k
Rx1_10_0 n1_10_0 n2_10_0 1k
Rz1_10_0 n1_10_0 n1_10_1 1k
Rg1_10_0 n1_10_0 0 50k
Rx1_10_1 n1_10_1 n2_10_1 1k
Rz1_10_1 n1_10_1 n1_10_2 1k
Rg1_10_1 n1_10_1 0 50k
Rx1_10_2 n1_10_2 n2_10_2 1k
Rz1_10_2 n1_10_2 n1_10_3 1k
Rg1_10_2 n1_10_2 0 50k
Rx1_10_3 n1_10_3 n2_10_3 1k
Rz1_10_3 n1_10_3 n1_10_4 1k
Rg1_10_3 n1_10_3 0 50k
Rx1_10_4 n1_10_4 n2_10_4 1k
Rz1_10_4 n1_10_4 n1_10_5 1k
Rg1_10_4 n1_10_4 0 50k
Rx1_10_5 n1_10_5 n2_10_5 1k
Rz1_10_5 n1_10_5 n1_10_6 1k
Rg1_10_5 n1_10_5 0 50k
Rx1_10_6 n1_10_6 n2_10_6 1k
Rz1_10_6 n1_10_6 n1_10_7 1k
Rg1_10_6 n1_10_6 0 50k
Rx1_10_7 n1_10_7 n2_10_7 1k
Rz1_10_7 n1_10_7 n1_10_8 1k
Rg1_10_7 n1_10_7 0 50k
Rx1_10_8 n1_10_8 n2_10_8 1k
Rz1_10_8 n1_10_8 n1_10_9 1k
Rg1_10_8 n1_10_8 0 50k
Rx1_10_9 n1_10_9 n2_10_9 1k
Rz1_10_9 n1_10_9 n1_10_10 1k
Rg1_10_9 n1_10_9 0 50k
Rx1_10_10 n1_10_10 n2_10_10 1k
Rg1_10_10 n1_10_10 0 50k
Rx2_0_0 n2_0_0 n3_0_0 1k
Ry2_0_0 n2_0_0 n2_1_0 1k
Rz2_0_0 n2_0_0 n2_0_1 1k
Rg2_0_0 n2_0_0 0 50k
Rx2_0_1 n2_0_1 n3_0_1 1k
Ry2_0_1 n2_0_1 n2_1_1 1k
Rz2_0_1 n2_0_1 n2_0_2 1k
Rg2_0_1 n2_0_1 0 50k
Rx2_0_2 n2_0_2 n3_0_2 1k
Ry2_0_2 n2_0_2 n2_1_2 1k
Rz2_0_2 n2_0_2 n2_0_3 1k
Rg2_0_2 n2_0_2 0 50k
Rx2_0_3 n2_0_3 n3_0_3 1k
Ry2_0_3 n2_0_3 n2_1_3 1k
Rz2_0_3 n2_0_3 n2_0_4 1k
Rg2_0_3 n2_0_3 0 50k
Rx2_0_4 n2_0_4 n3_0_4 1k
Ry2_0_4 n2_0_4 n2_1_4 1k
Rz2_0_4 n2_0_4 n2_0_5 1k
Rg2_0_4 n2_0_4 0 50k
Rx2_0_5 n2_0_5 n3_0_5 1k
Ry2_0_5 n2_0_5 n2_1_5 1k
Rz2_0_5 n2_0_5 n2_0_6 1k
Rg2_0_5 n2_0_5 0 50k
Rx2_0_6 n2_0_6 n3_0_6 1k
Ry2_0_6 n2_0_6 n2_1_6 1k
Rz2_0_6 n2_0_6 n2_0_7 1k
Rg2_0_6 n2_0_6 0 50k
Rx2_0_7 n2_0_7 n3_0_7 1k
Ry2_0_7 n2_0_7 n2_1_7 1k
Rz2_0_7 n2_0_7 n2_0_8 1k
Rg2_0_7 n2_0_7 0 50k
Rx2_0_8 n2_0_8 n3_0_8 1k
Ry2_0_8 n2_0_8 n2_1_8 1k
Rz2_0_8 n2_0_8 n2_0_9 1k
Rg2_0_8 n2_0_8 0 50k
Rx2_0_9 n2_0_9 n3_0_9 1k
Ry2_0_9 n2_0_9 n2_1_9 1k
Rz2_0_9 n2_0_9 n2_0_10 1k
Rg2_0_9 n2_0_9 0 50k
Rx2_0_10 n2_0_10 n3_0_10 1k
Ry2_0_10 n2_0_10 n2_1_10 1k
Rg2_0_10 n2_0_10 0 50k
Rx2_1_0 n2_1_0 n3_1_0 1k
Ry2_1_0 n2_1_0 n2_2_0 1k
Rz2_1_0 n2_1_0 n2_1_1 1k
Rg2_1_0 n2_1_0 0 50k
Rx2_1_1 n2_1_1 n3_1_1 1k
Ry2_1_1 n2_1_1 n2_2_1 1k
Rz2_1_1 n2_1_1 n2_1_2 1k
Rg2_1_1 n2_1_1 0 50k
Rx2_1_2 n2_1_2 n3_1_2 1k
Ry2_1_2 n2_1_2 n2_2_2 1k
Rz2_1_2 n2_1_2 n2_1_3 1k
Rg2_1_2 n2_1_2 0 50k
Rx2_1_3 n2_1_3 n3_1_3 1k
Ry2_1_3 n2_1_3 n2_2_3 1k
Rz2_1_3 n2_1_3 n2_1_4 1k
Rg2_1_3 n2_1_3 0 50k
Rx2_1_4 n2_1_4 n3_1_4 1k
Ry2_1_4 n2_1_4 n2_2_4 1k
Rz2_1_4 n2_1_4 n2_1_5 1k
Rg2_1_4 n2_1_4 0 50k
Rx2_1_5 n2_1_5 n3_1_5 1k
Ry2_1_5 n2_1_5 n2_2_5 1k
Rz2_1_5 n2_1_5 n2_1_6 1k
Rg2_1_5 n2_1_5 0 50k
Rx2_1_6 n2_1_6 n3_1_6 1k
Ry2_1_6 n2_1_6 n2_2_6 1k
Rz2_1_6 n2_1_6 n2_1_7 1k
Rg2_1_6 n2_1_6 0 50k
Rx2_1_7 n2_1_7 n3_1_7 1k
Ry2_1_7 n2_1_7 n2_2_7 1k
Rz2_1_7 n2_1_7 n2_1_8 1k
Rg2_1_7 n2_1_7 0 50k
Rx2_1_8 n2_1_8 n3_1_8 1k
Ry2_1_8 n2_1_8 n2_2_8 1k
Rz2_1_8 n2_1_8 n2_1_9 1k
Rg2_1_8 n2_1_8 0 50k
Rx2_1_9 n2_1_9 n3_1_9 1k
Ry2_1_9 n2_1_9 n2_2_9 1k
Rz2_1_9 n2_1_9 n2_1_10 1k
Rg2_1_9 n2_1_9 0 50k
Rx2_1_10 n2_1_10 n3_1_10 1k
Ry2_1_10 n2_1_10 n2_2_10 1k
Rg2_1_10 n2_1_10 0 50k
Rx2_2_0 n2_2_0 n3_2_0 1k
Ry2_2_0 n2_2_0 n2_3_0 1k
Rz2_2_0 n2_2_0 n2_2_1 1k
Rg2_2_0 n2_2_0 0 50k
Rx2_2_1 n2_2_1 n3_2_1 1k
Ry2_2_1 n2_2_1 n2_3_1 1k
Rz2_2_1 n2_2_1 n2_2_2 1k
Rg2_2_1 n2_2_1 0 50k
Rx2_2_2 n2_2_2 n3_2_2 1k
Ry2_2_2 n2_2_2 n2_3_2 1k
Rz2_2_2 n2_2_2 n2_2_3 1k
Rg2_2_2 n2_2_2 0 50k
Rx2_2_3 n2_2_3 n3_2_3 1k
Ry2_2_3 n2_2_3 n2_3_3 1k
Rz2_2_3 n2_2_3 n2_2_4 1k
Rg2_2_3 n2_2_3 0 50k
Rx2_2_4 n2_2_4 n3_2_4 1k
Ry2_2_4 n2_2_4 n2_3_4 1k
Rz2_2_4 n2_2_4 n2_2_5 1k
Rg2_2_4 n2_2_4 0 50k
Rx2_2_5 n2_2_5 n3_2_5 1k
Ry2_2_5 n2_2_5 n2_3_5 1k
Rz2_2_5 n2_2_5 n2_2_6 1k
Rg2_2_5 n2_2_5 0 50k
Rx2_2_6 n2_2_6 n3_2_6 1k
Ry2_2_6 n2_2_6 n2_3_6 1k
Rz2_2_6 n2_2_6 n2_2_7 1k
Rg2_2_6 n2_2_6 0 50k
Rx2_2_7 n2_2_7 n3_2_7 1k
Ry2_2_7 n2_2_7 n2_3_7 1k
Rz2_2_7 n2_2_7 n2_2_8 1k
Rg2_2_7 n2_2_7 0 50k
Rx2_2_8 n2_2_8 n3_2_8 1k
Ry2_2_8 n2_2_8 n2_3_8 1k
Rz2_2_8 n2_2_8 n2_2_9 1k
Rg2_2_8 n2_2_8 0 50k
Rx2_2_9 n2_2_9 n3_2_9 1k
Ry2_2_9 n2_2_9 n2_3_9 1k
Rz2_2_9 n2_2_9 n2_2_10 1k
Rg2_2_9 n2_2_9 0 50k
Rx2_2_10 n2_2_10 n3_2_10 1k
Ry2_2_10 n2_2_10 n2_3_10 1k
Rg2_2_10 n2_2_10 0 50k
Rx2_3_0 n2_3_0 n3_3_0 1k
Ry2_3_0 n2_3_0 n2_4_0 1k
Rz2_3_0 n2_3_0 n2_3_1 1k
Rg2_3_0 n2_3_0 0 50k
Rx2_3_1 n2_3_1 n3_3_1 1k
Ry2_3_1 n2_3_1 n2_4_1 1k
Rz2_3_1 n2_3_1 n2_3_2 1k
Rg2_3_1 n2_3_1 0 50k
Rx2_3_2 n2_3_2 n3_3_2 1k
Ry2_3_2 n2_3_2 n2_4_2 1k
Rz2_3_2 n2_3_2 n2_3_3 1k
Rg2_3_2 n2_3_2 0 50k
Rx2_3_3 n2_3_3 n3_3_3 1k
Ry2_3_3 n2_3_3 n2_4_3 1k
Rz2_3_3 n2_3_3 n2_3_4 1k
Rg2_3_3 n2_3_3 0 50k
Rx2_3_4 n2_3_4 n3_3_4 1k
Ry2_3_4 n2_3_4 n2_4_4 1k
Rz2_3_4 n2_3_4 n2_3_5 1k
Rg2_3_4 n2_3_4 0 50k
Rx2_3_5 n2_3_5 n3_3_5 1k
Ry2_3_5 n2_3_5 n2_4_5 1k
Rz2_3_5 n2_3_5 n2_3_6 1k
Rg2_3_5 n2_3_5 0 50k
Rx2_3_6 n2_3_6 n3_3_6 1k
Ry2_3_6 n2_3_6 n2_4_6 1k
Rz2_3_6 n2_3_6 n2_3_7 1k
Rg2_3_6 n2_3_6 0 50k
Rx2_3_7 n2_3_7 n3_3_7 1k
Ry2_3_7 n2_3_7 n2_4_7 1k
Rz2_3_7 n2_3_7 n2_3_8 1k
Rg2_3_7 n2_3_7 0 50k
Rx2_3_8 n2_3_8 n3_3_8 1k
Ry2_3_8 n2_3_8 n2_4_8 1k
Rz2_3_8 n2_3_8 n2_3_9 1k
Rg2_3_8 n2_3_8 0 50k
Rx2_3_9 n2_3_9 n3_3_9 1k
Ry2_3_9 n2_3_9 n2_4_9 1k
Rz2_3_9 n2_3_9 n2_3_10 1k
Rg2_3_9 n2_3_9 0 50k
Rx2_3_10 n2_3_10 n3_3_10 1k
Ry2_3_10 n2_3_10 n2_4_10 1k
Rg2_3_10 n2_3_10 0 50k
Rx2_4_0 n2_4_0 n3_4_0 1k
Ry2_4_0 n2_4_0 n2_5_0 1k
Rz2_4_0 n2_4_0 n2_4_1 1k
Rg2_4_0 n2_4_0 0 50k
Rx2_4_1 n2_4_1 n3_4_1 1k
Ry2_4_1 n2_4_1 n2_5_1 1k
Rz2_4_1 n2_4_1 n2_4_2 1k
Rg2_4_1 n2_4_1 0 50k
Rx2_4_2 n2_4_2 n3_4_2 1k
Ry2_4_2 n2_4_2 n2_5_2 1k
Rz2_4_2 n2_4_2 n2_4_3 1k
Rg2_4_2 n2_4_2 0 50k
Rx2_4_3 n2_4_3 n3_4_3 1k
Ry2_4_3 n2_4_3 n2_5_3 1k
Rz2_4_3 n2_4_3 n2_4_4 1k
Rg2_4_3 n2_4_3 0 50k
Rx2_4_4 n2_4_4 n3_4_4 1k
Ry2_4_4 n2_4_4 n2_5_4 1k
Rz2_4_4 n2_4_4 n2_4_5 1k
Rg2_4_4 n2_4_4 0 50k
Rx2_4_5 n2_4_5 n3_4_5 1k
Ry2_4_5 n2_4_5 n2_5_5 1k
Rz2_4_5 n2_4_5 n2_4_6 1k
Rg2_4_5 n2_4_5 0 50k
Rx2_4_6 n2_4_6 n3_4_6 1k
Ry2_4_6 n2_4_6 n2_5_6 1k
Rz2_4_6 n2_4_6 n2_4_7 1k
Rg2_4_6 n2_4_6 0 50k
Rx2_4_7 n2_4_7 n3_4_7 1k
Ry2_4_7 n2_4_7 n2_5_7 1k
Rz2_4_7 n2_4_7 n2_4_8 1k
Rg2_4_7 n2_4_7 0 50k
Rx2_4_8 n2_4_8 n3_4_8 1k
Ry2_4_8 n2_4_8 n2_5_8 1k
Rz2_4_8 n2_4_8 n2_4_9 1k
Rg2_4_8 n2_4_8 0 50k
Rx2_4_9 n2_4_9 n3_4_9 1k
Ry2_4_9 n2_4_9 n2_5_9 1k
Rz2_4_9 n2_4_9 n2_4_10 1k
Rg2_4_9 n2_4_9 0 50k
Rx2_4_10 n2_4_10 n3_4_10 1k
Ry2_4_10 n2_4_10 n2_5_10 1k
Rg2_4_10 n2_4_10 0 50k
Rx2_5_0 n2_5_0 n3_5_0 1k
Ry2_5_0 n2_5_0 n2_6_0 1k
Rz2_5_0 n2_5_0 n2_5_1 1k
Rg2_5_0 n2_5_0 0 50k
Rx2_5_1 n2_5_1 n3_5_1 1k
Ry2_5_1 n2_5_1 n2_6_1 1k
Rz2_5_1 n2_5_1 n2_5_2 1k
Rg2_5_1 n2_5_1 0 50k
Rx2_5_2 n2_5_2 n3_5_2 1k
Ry2_5_2 n2_5_2 n2_6_2 1k
Rz2_5_2 n2_5_2 n2_5_3 1k
Rg2_5_2 n2_5_2 0 50k
Rx2_5_3 n2_5_3 n3_5_3 1k
Ry2_5_3 n2_5_3 n2_6_3 1k
Rz2_5_3 n2_5_3 n2_5_4 1k
Rg2_5_3 n2_5_3 0 50k
Rx2_5_4 n2_5_4 n3_5_4 1k
Ry2_5_4 n2_5_4 n2_6_4 1k
Rz2_5_4 n2_5_4 n2_5_5 1k
Rg2_5_4 n2_5_4 0 50k
Rx2_5_5 n2_5_5 n3_5_5 1k
Ry2_5_5 n2_5_5 n2_6_5 1k
Rz2_5_5 n2_5_5 n2_5_6 1k
Rg2_5_5 n2_5_5 0 50k
Rx2_5_6 n2_5_6 n3_5_6 1k
Ry2_5_6 n2_5_6 n2_6_6 1k
Rz2_5_6 n2_5_6 n2_5_7 1k
Rg2_5_6 n2_5_6 0 50k
Rx2_5_7 n2_5_7 n3_5_7 1k
Ry2_5_7 n2_5_7 n2_6_7 1k
Rz2_5_7 n2_5_7 n2_5_8 1k
Rg2_5_7 n2_5_7 0 50k
Rx2_5_8 n2_5_8 n3_5_8 1k
Ry2_5_8 n2_5_8 n2_6_8 1k
Rz2_5_8 n2_5_8 n2_5_9 1k
Rg2_5_8 n2_5_8 0 50k
Rx2_5_9 n2_5_9 n3_5_9 1k
Ry2_5_9 n2_5_9 n2_6_9 1k
Rz2_5_9 n2_5_9 n2_5_10 1k
Rg2_5_9 n2_5_9 0 50k
Rx2_5_10 n2_5_10 n3_5_10 1k
Ry2_5_10 n2_5_10 n2_6_10 1k
Rg2_5_10 n2_5_10 0 50k
Rx2_6_0 n2_6_0 n3_6_0 1k
Ry2_6_0 n2_6_0 n2_7_0 1k
Rz2_6_0 n2_6_0 n2_6_1 1k
Rg2_6_0 n2_6_0 0 50k
Rx2_6_1 n2_6_1 n3_6_1 1k
Ry2_6_1 n2_6_1 n2_7_1 1k
Rz2_6_1 n2_6_1 n2_6_2 1k
Rg2_6_1 n2_6_1 0 50k
Rx2_6_2 n2_6_2 n3_6_2 1k
Ry2_6_2 n2_6_2 n2_7_2 1k
Rz2_6_2 n2_6_2 n2_6_3 1k
Rg2_6_2 n2_6_2 0 50k
Rx2_6_3 n2_6_3 n3_6_3 1k
Ry2_6_3 n2_6_3 n2_7_3 1k
Rz2_6_3 n2_6_3 n2_6_4 1k
Rg2_6_3 n2_6_3 0 50k
Rx2_6_4 n2_6_4 n3_6_4 1k
Ry2_6_4 n2_6_4 n2_7_4 1k
Rz2_6_4 n2_6_4 n2_6_5 1k
Rg2_6_4 n2_6_4 0 50k
Rx2_6_5 n2_6_5 n3_6_5 1k
Ry2_6_5 n2_6_5 n2_7_5 1k
Rz2_6_5 n2_6_5 n2_6_6 1k
Rg2_6_5 n2_6_5 0 50k
Rx2_6_6 n2_6_6 n3_6_6 1k
Ry2_6_6 n2_6_6 n2_7_6 1k
Rz2_6_6 n2_6_6 n2_6_7 1k
Rg2_6_6 n2_6_6 0 50k
Rx2_6_7 n2_6_7 n3_6_7 1k
Ry2_6_7 n2_6_7 n2_7_7 1k
Rz2_6_7 n2_6_7 n2_6_8 1k
Rg2_6_7 n2_6_7 0 50k
Rx2_6_8 n2_6_8 n3_6_8 1k
Ry2_6_8 n2_6_8 n2_7_8 1k
Rz2_6_8 n2_6_8 n2_6_9 1k
Rg2_6_8 n2_6_8 0 50k
Rx2_6_9 n2_6_9 n3_6_9 1k
Ry2_6_9 n2_6_9 n2_7_9 1k
Rz2_6_9 n2_6_9 n2_6_10 1k
Rg2_6_9 n2_6_9 0 50k
Rx2_6_10 n2_6_10 n3_6_10 1k
Ry2_6_10 n2_6_10 n2_7_10 1k
Rg2_6_10 n2_6_10 0 50k
Rx2_7_0 n2_7_0 n3_7_0 1k
Ry2_7_0 n2_7_0 n2_8_0 1k
Rz2_7_0 n2_7_0 n2_7_1 1k
Rg2_7_0 n2_7_0 0 50k
Rx2_7_1 n2_7_1 n3_7_1 1k
Ry2_7_1 n2_7_1 n2_8_1 1k
Rz2_7_1 n2_7_1 n2_7_2 1k
Rg2_7_1 n2_7_1 0 50k
Rx2_7_2 n2_7_2 n3_7_2 1k
Ry2_7_2 n2_7_2 n2_8_2 1k
Rz2_7_2 n2_7_2 n2_7_3 1k
Rg2_7_2 n2_7_2 0 50k
Rx2_7_3 n2_7_3 n3_7_3 1k
Ry2_7_3 n2_7_3 n2_8_3 1k
Rz2_7_3 n2_7_3 n2_7_4 1k
Rg2_7_3 n2_7_3 0 50k
Rx2_7_4 n2_7_4 n3_7_4 1k
Ry2_7_4 n2_7_4 n2_8_4 1k
Rz2_7_4 n2_7_4 n2_7_5 1k
Rg2_7_4 n2_7_4 0 50k
Rx2_7_5 n2_7_5 n3_7_5 1k
Ry2_7_5 n2_7_5 n2_8_5 1k
Rz2_7_5 n2_7_5 n2_7_6 1k
Rg2_7_5 n2_7_5 0 50k
Rx2_7_6 n2_7_6 n3_7_6 1k
Ry2_7_6 n2_7_6 n2_8_6 1k
Rz2_7_6 n2_7_6 n2_7_7 1k
Rg2_7_6 n2_7_6 0 50k
Rx2_7_7 n2_7_7 n3_7_7 1k
Ry2_7_7 n2_7_7 n2_8_7 1k
Rz2_7_7 n2_7_7 n2_7_8 1k
Rg2_7_7 n2_7_7 0 50k
Rx2_7_8 n2_7_8 n3_7_8 1k
Ry2_7_8 n2_7_8 n2_8_8 1k
Rz2_7_8 n2_7_8 n2_7_9 1k
Rg2_7_8 n2_7_8 0 50k
Rx2_7_9 n2_7_9 n3_7_9 1k
Ry2_7_9 n2_7_9 n2_8_9 1k
Rz2_7_9 n2_7_9 n2_7_10 1k
Rg2_7_9 n2_7_9 0 50k
Rx2_7_10 n2_7_10 n3_7_10 1k
Ry2_7_10 n2_7_10 n2_8_10 1k
Rg2_7_10 n2_7_10 0 50k
Rx2_8_0 n2_8_0 n3_8_0 1k
Ry2_8_0 n2_8_0 n2_9_0 1k
Rz2_8_0 n2_8_0 n2_8_1 1k
Rg2_8_0 n2_8_0 0 50k
Rx2_8_1 n2_8_1 n3_8_1 1k
Ry2_8_1 n2_8_1 n2_9_1 1k
Rz2_8_1 n2_8_1 n2_8_2 1k
Rg2_8_1 n2_8_1 0 50k
Rx2_8_2 n2_8_2 n3_8_2 1k
Ry2_8_2 n2_8_2 n2_9_2 1k
Rz2_8_2 n2_8_2 n2_8_3 1k
Rg2_8_2 n2_8_2 0 50k
Rx2_8_3 n2_8_3 n3_8_3 1k
Ry2_8_3 n2_8_3 n2_9_3 1k
Rz2_8_3 n2_8_3 n2_8_4 1k
Rg2_8_3 n2_8_3 0 50k
Rx2_8_4 n2_8_4 n3_8_4 1k
Ry2_8_4 n2_8_4 n2_9_4 1k
Rz2_8_4 n2_8_4 n2_8_5 1k
Rg2_8_4 n2_8_4 0 50k
Rx2_8_5 n2_8_5 n3_8_5 1k
Ry2_8_5 n2_8_5 n2_9_5 1k
Rz2_8_5 n2_8_5 n2_8_6 1k
Rg2_8_5 n2_8_5 0 50k
Rx2_8_6 n2_8_6 n3_8_6 1k
Ry2_8_6 n2_8_6 n2_9_6 1k
Rz2_8_6 n2_8_6 n2_8_7 1k
Rg2_8_6 n2_8_6 0 50k
Rx2_8_7 n2_8_7 n3_8_7 1k
Ry2_8_7 n2_8_7 n2_9_7 1k
Rz2_8_7 n2_8_7 n2_8_8 1k
Rg2_8_7 n2_8_7 0 50k
Rx2_8_8 n2_8_8 n3_8_8 1k
Ry2_8_8 n2_8_8 n2_9_8 1k
Rz2_8_8 n2_8_8 n2_8_9 1k
Rg2_8_8 n2_8_8 0 50k
Rx2_8_9 n2_8_9 n3_8_9 1k
Ry2_8_9 n2_8_9 n2_9_9 1k
Rz2_8_9 n2_8_9 n2_8_10 1k
Rg2_8_9 n2_8_9 0 50k
Rx2_8_10 n2_8_10 n3_8_10 1k
Ry2_8_10 n2_8_10 n2_9_10 1k
Rg2_8_10 n2_8_10 0 50k
Rx2_9_0 n2_9_0 n3_9_0 1k
Ry2_9_0 n2_9_0 n2_10_0 1k
Rz2_9_0 n2_9_0 n2_9_1 1k
Rg2_9_0 n2_9_0 0 50k
Rx2_9_1 n2_9_1 n3_9_1 1k
Ry2_9_1 n2_9_1 n2_10_1 1k
Rz2_9_1 n2_9_1 n2_9_2 1k
Rg2_9_1 n2_9_1 0 50k
Rx2_9_2 n2_9_2 n3_9_2 1k
Ry2_9_2 n2_9_2 n2_10_2 1k
Rz2_9_2 n2_9_2 n2_9_3 1k
Rg2_9_2 n2_9_2 0 50k
Rx2_9_3 n2_9_3 n3_9_3 1k
Ry2_9_3 n2_9_3 n2_10_3 1k
Rz2_9_3 n2_9_3 n2_9_4 1k
Rg2_9_3 n2_9_3 0 50k
Rx2_9_4 n2_9_4 n3_9_4 1k
Ry2_9_4 n2_9_4 n2_10_4 1k
Rz2_9_4 n2_9_4 n2_9_5 1k
Rg2_9_4 n2_9_4 0 50k
Rx2_9_5 n2_9_5 n3_9_5 1k
Ry2_9_5 n2_9_5 n2_10_5 1k
Rz2_9_5 n2_9_5 n2_9_6 1k
Rg2_9_5 n2_9_5 0 50k
Rx2_9_6 n2_9_6 n3_9_6 1k
Ry2_9_6 n2_9_6 n2_10_6 1k
Rz2_9_6 n2_9_6 n2_9_7 1k
Rg2_9_6 n2_9_6 0 50k
Rx2_9_7 n2_9_7 n3_9_7 1k
Ry2_9_7 n2_9_7 n2_10_7 1k
Rz2_9_7 n2_9_7 n2_9_8 1k
Rg2_9_7 n2_9_7 0 50k
Rx2_9_8 n2_9_8 n3_9_8 1k
Ry2_9_8 n2_9_8 n2_10_8 1k
Rz2_9_8 n2_9_8 n2_9_9 1k
Rg2_9_8 n2_9_8 0 50k
Rx2_9_9 n2_9_9 n3_9_9 1k
Ry2_9_9 n2_9_9 n2_10_9 1k
Rz2_9_9 n2_9_9 n2_9_10 1k
Rg2_9_9 n2_9_9 0 50k
Rx2_9_10 n2_9_10 n3_9_10 1k
Ry2_9_10 n2_9_10 n2_10_10 1k
Rg2_9_10 n2_9_10 0 50k
Rx2_10_0 n2_10_0 n3_10_0 1k
Rz2_10_0 n2_10_0 n2_10_1 1k
Rg2_10_0 n2_10_0 0 50k
Rx2_10_1 n2_10_1 n3_10_1 1k
Rz2_10_1 n2_10_1 n2_10_2 1k
Rg2_10_1 n2_10_1 0 50k
Rx2_10_2 n2_10_2 n3_10_2 1k
Rz2_10_2 n2_10_2 n2_10_3 1k
Rg2_10_2 n2_10_2 0 50k
Rx2_10_3 n2_10_3 n3_10_3 1k
Rz2_10_3 n2_10_3 n2_10_4 1k
Rg2_10_3 n2_10_3 0 50k
Rx2_10_4 n2_10_4 n3_10_4 1k
Rz2_10_4 n2_10_4 n2_10_5 1k
Rg2_10_4 n2_10_4 0 50k
Rx2_10_5 n2_10_5 n3_10_5 1k
Rz2_10_5 n2_10_5 n2_10_6 1k
Rg2_10_5 n2_10_5 0 50k
Rx2_10_6 n2_10_6 n3_10_6 1k
Rz2_10_6 n2_10_6 n2_10_7 1k
Rg2_10_6 n2_10_6 0 50k
Rx2_10_7 n2_10_7 n3_10_7 1k
Rz2_10_7 n2_10_7 n2_10_8 1k
Rg2_10_7 n2_10_7 0 50k
Rx2_10_8 n2_10_8 n3_10_8 1k
Rz2_10_8 n2_10_8 n2_10_9 1k
Rg2_10_8 n2_10_8 0 50k
Rx2_10_9 n2_10_9 n3_10_9 1k
Rz2_10_9 n2_10_9 n2_10_10 1k
Rg2_10_9 n2_10_9 0 50k
Rx2_10_10 n2_10_10 n3_10_10 1k
Rg2_10_10 n2_10_10 0 50k
Rx3_0_0 n3_0_0 n4_0_0 1k
Ry3_0_0 n3_0_0 n3_1_0 1k
Rz3_0_0 n3_0_0 n3_0_1 1k
Rg3_0_0 n3_0_0 0 50k
Rx3_0_1 n3_0_1 n4_0_1 1k
Ry3_0_1 n3_0_1 n3_1_1 1k
Rz3_0_1 n3_0_1 n3_0_2 1k
Rg3_0_1 n3_0_1 0 50k
Rx3_0_2 n3_0_2 n4_0_2 1k
Ry3_0_2 n3_0_2 n3_1_2 1k
Rz3_0_2 n3_0_2 n3_0_3 1k
Rg3_0_2 n3_0_2 0 50k
Rx3_0_3 n3_0_3 n4_0_3 1k
Ry3_0_3 n3_0_3 n3_1_3 1k
Rz3_0_3 n3_0_3 n3_0_4 1k
Rg3_0_3 n3_0_3 0 50k
Rx3_0_4 n3_0_4 n4_0_4 1k
Ry3_0_4 n3_0_4 n3_1_4 1k
Rz3_0_4 n3_0_4 n3_0_5 1k
Rg3_0_4 n3_0_4 0 50k
Rx3_0_5 n3_0_5 n4_0_5 1k
Ry3_0_5 n3_0_5 n3_1_5 1k
Rz3_0_5 n3_0_5 n3_0_6 1k
Rg3_0_5 n3_0_5 0 50k
Rx3_0_6 n3_0_6 n4_0_6 1k
Ry3_0_6 n3_0_6 n3_1_6 1k
Rz3_0_6 n3_0_6 n3_0_7 1k
Rg3_0_6 n3_0_6 0 50k
Rx3_0_7 n3_0_7 n4_0_7 1k
Ry3_0_7 n3_0_7 n3_1_7 1k
Rz3_0_7 n3_0_7 n3_0_8 1k
Rg3_0_7 n3_0_7 0 50k
Rx3_0_8 n3_0_8 n4_0_8 1k
Ry3_0_8 n3_0_8 n3_1_8 1k
Rz3_0_8 n3_0_8 n3_0_9 1k
Rg3_0_8 n3_0_8 0 50k
Rx3_0_9 n3_0_9 n4_0_9 1k
Ry3_0_9 n3_0_9 n3_1_9 1k
Rz3_0_9 n3_0_9 n3_0_10 1k
Rg3_0_9 n3_0_9 0 50k
Rx3_0_10 n3_0_10 n4_0_10 1k
Ry3_0_10 n3_0_10 n3_1_10 1k
Rg3_0_10 n3_0_10 0 50k
Rx3_1_0 n3_1_0 n4_1_0 1k
Ry3_1_0 n3_1_0 n3_2_0 1k
Rz3_1_0 n3_1_0 n3_1_1 1k
Rg3_1_0 n3_1_0 0 50k
Rx3_1_1 n3_1_1 n4_1_1 1k
Ry3_1_1 n3_1_1 n3_2_1 1k
Rz3_1_1 n3_1_1 n3_1_2 1k
Rg3_1_1 n3_1_1 0 50k
Rx3_1_2 n3_1_2 n4_1_2 1k
Ry3_1_2 n3_1_2 n3_2_2 1k
Rz3_1_2 n3_1_2 n3_1_3 1k
Rg3_1_2 n3_1_2 0 50k
Rx3_1_3 n3_1_3 n4_1_3 1k
Ry3_1_3 n3_1_3 n3_2_3 1k
Rz3_1_3 n3_1_3 n3_1_4 1k
Rg3_1_3 n3_1_3 0 50k
Rx3_1_4 n3_1_4 n4_1_4 1k
Ry3_1_4 n3_1_4 n3_2_4 1k
Rz3_1_4 n3_1_4 n3_1_5 1k
Rg3_1_4 n3_1_4 0 50k
Rx3_1_5 n3_1_5 n4_1_5 1k
Ry3_1_5 n3_1_5 n3_2_5 1k
Rz3_1_5 n3_1_5 n3_1_6 1k
Rg3_1_5 n3_1_5 0 50k
Rx3_1_6 n3_1_6 n4_1_6 1k
Ry3_1_6 n3_1_6 n3_2_6 1k
Rz3_1_6 n3_1_6 n3_1_7 1k
Rg3_1_6 n3_1_6 0 50k
Rx3_1_7 n3_1_7 n4_1_7 1k
Ry3_1_7 n3_1_7 n3_2_7 1k
Rz3_1_7 n3_1_7 n3_1_8 1k
Rg3_1_7 n3_1_7 0 50k
Rx3_1_8 n3_1_8 n4_1_8 1k
Ry3_1_8 n3_1_8 n3_2_8 1k
Rz3_1_8 n3_1_8 n3_1_9 1k
Rg3_1_8 n3_1_8 0 50k
Rx3_1_9 n3_1_9 n4_1_9 1k
Ry3_1_9 n3_1_9 n3_2_9 1k
Rz3_1_9 n3_1_9 n3_1_10 1k
Rg3_1_9 n3_1_9 0 50k
Rx3_1_10 n3_1_10 n4_1_10 1k
Ry3_1_10 n3_1_10 n3_2_10 1k
Rg3_1_10 n3_1_10 0 50k
Rx3_2_0 n3_2_0 n4_2_0 1k
Ry3_2_0 n3_2_0 n3_3_0 1k
Rz3_2_0 n3_2_0 n3_2_1 1k
Rg3_2_0 n3_2_0 0 50k
Rx3_2_1 n3_2_1 n4_2_1 1k
Ry3_2_1 n3_2_1 n3_3_1 1k
Rz3_2_1 n3_2_1 n3_2_2 1k
Rg3_2_1 n3_2_1 0 50k
Rx3_2_2 n3_2_2 n4_2_2 1k
Ry3_2_2 n3_2_2 n3_3_2 1k
Rz3_2_2 n3_2_2 n3_2_3 1k
Rg3_2_2 n3_2_2 0 50k
Rx3_2_3 n3_2_3 n4_2_3 1k
Ry3_2_3 n3_2_3 n3_3_3 1k
Rz3_2_3 n3_2_3 n3_2_4 1k
Rg3_2_3 n3_2_3 0 50k
Rx3_2_4 n3_2_4 n4_2_4 1k
Ry3_2_4 n3_2_4 n3_3_4 1k
Rz3_2_4 n3_2_4 n3_2_5 1k
Rg3_2_4 n3_2_4 0 50k
Rx3_2_5 n3_2_5 n4_2_5 1k
Ry3_2_5 n3_2_5 n3_3_5 1k
Rz3_2_5 n3_2_5 n3_2_6 1k
Rg3_2_5 n3_2_5 0 50k
Rx3_2_6 n3_2_6 n4_2_6 1k
Ry3_2_6 n3_2_6 n3_3_6 1k
Rz3_2_6 n3_2_6 n3_2_7 1k
Rg3_2_6 n3_2_6 0 50k
Rx3_2_7 n3_2_7 n4_2_7 1k
Ry3_2_7 n3_2_7 n3_3_7 1k
Rz3_2_7 n3_2_7 n3_2_8 1k
Rg3_2_7 n3_2_7 0 50k
Rx3_2_8 n3_2_8 n4_2_8 1k
Ry3_2_8 n3_2_8 n3_3_8 1k
Rz3_2_8 n3_2_8 n3_2_9 1k
Rg3_2_8 n3_2_8 0 50k
Rx3_2_9 n3_2_9 n4_2_9 1k
Ry3_2_9 n3_2_9 n3_3_9 1k
Rz3_2_9 n3_2_9 n3_2_10 1k
Rg3_2_9 n3_2_9 0 50k
Rx3_2_10 n3_2_10 n4_2_10 1k
Ry3_2_10 n3_2_10 n3_3_10 1k
Rg3_2_10 n3_2_10 0 50k
Rx3_3_0 n3_3_0 n4_3_0 1k
Ry3_3_0 n3_3_0 n3_4_0 1k
Rz3_3_0 n3_3_0 n3_3_1 1k
Rg3_3_0 n3_3_0 0 50k
Rx3_3_1 n3_3_1 n4_3_1 1k
Ry3_3_1 n3_3_1 n3_4_1 1k
Rz3_3_1 n3_3_1 n3_3_2 1k
Rg3_3_1 n3_3_1 0 50k
Rx3_3_2 n3_3_2 n4_3_2 1k
Ry3_3_2 n3_3_2 n3_4_2 1k
Rz3_3_2 n3_3_2 n3_3_3 1k
Rg3_3_2 n3_3_2 0 50k
Rx3_3_3 n3_3_3 n4_3_3 1k
Ry3_3_3 n3_3_3 n3_4_3 1k
Rz3_3_3 n3_3_3 n3_3_4 1k
Rg3_3_3 n3_3_3 0 50k
Rx3_3_4 n3_3_4 n4_3_4 1k
Ry3_3_4 n3_3_4 n3_4_4 1k
Rz3_3_4 n3_3_4 n3_3_5 1k
Rg3_3_4 n3_3_4 0 50k
Rx3_3_5 n3_3_5 n4_3_5 1k
Ry3_3_5 n3_3_5 n3_4_5 1k
Rz3_3_5 n3_3_5 n3_3_6 1k
Rg3_3_5 n3_3_5 0 50k
Rx3_3_6 n3_3_6 n4_3_6 1k
Ry3_3_6 n3_3_6 n3_4_6 1k
Rz3_3_6 n3_3_6 n3_3_7 1k
Rg3_3_6 n3_3_6 0 50k
Rx3_3_7 n3_3_7 n4_3_7 1k
Ry3_3_7 n3_3_7 n3_4_7 1k
Rz3_3_7 n3_3_7 n3_3_8 1k
Rg3_3_7 n3_3_7 0 50k
Rx3_3_8 n3_3_8 n4_3_8 1k
Ry3_3_8 n3_3_8 n3_4_8 1k
Rz3_3_8 n3_3_8 n3_3_9 1k
Rg3_3_8 n3_3_8 0 50k
Rx3_3_9 n3_3_9 n4_3_9 1k
Ry3_3_9 n3_3_9 n3_4_9 1k
Rz3_3_9 n3_3_9 n3_3_10 1k
Rg3_3_9 n3_3_9 0 50k
Rx3_3_10 n3_3_10 n4_3_10 1k
Ry3_3_10 n3_3_10 n3_4_10 1k
Rg3_3_10 n3_3_10 0 50k
Rx3_4_0 n3_4_0 n4_4_0 1k
Ry3_4_0 n3_4_0 n3_5_0 1k
Rz3_4_0 n3_4_0 n3_4_1 1k
Rg3_4_0 n3_4_0 0 50k
Rx3_4_1 n3_4_1 n4_4_1 1k
Ry3_4_1 n3_4_1 n3_5_1 1k
Rz3_4_1 n3_4_1 n3_4_2 1k
Rg3_4_1 n3_4_1 0 50k
Rx3_4_2 n3_4_2 n4_4_2 1k
Ry3_4_2 n3_4_2 n3_5_2 1k
Rz3_4_2 n3_4_2 n3_4_3 1k
Rg3_4_2 n3_4_2 0 50k
Rx3_4_3 n3_4_3 n4_4_3 1k
Ry3_4_3 n3_4_3 n3_5_3 1k
Rz3_4_3 n3_4_3 n3_4_4 1k
Rg3_4_3 n3_4_3 0 50k
Rx3_4_4 n3_4_4 n4_4_4 1k
Ry3_4_4 n3_4_4 n3_5_4 1k
Rz3_4_4 n3_4_4 n3_4_5 1k
Rg3_4_4 n3_4_4 0 50k
Rx3_4_5 n3_4_5 n4_4_5 1k
Ry3_4_5 n3_4_5 n3_5_5 1k
Rz3_4_5 n3_4_5 n3_4_6 1k
Rg3_4_5 n3_4_5 0 50k
Rx3_4_6 n3_4_6 n4_4_6 1k
Ry3_4_6 n3_4_6 n3_5_6 1k
Rz3_4_6 n3_4_6 n3_4_7 1k
Rg3_4_6 n3_4_6 0 50k
Rx3_4_7 n3_4_7 n4_4_7 1k
Ry3_4_7 n3_4_7 n3_5_7 1k
Rz3_4_7 n3_4_7 n3_4_8 1k
Rg3_4_7 n3_4_7 0 50k
Rx3_4_8 n3_4_8 n4_4_8 1k
Ry3_4_8 n3_4_8 n3_5_8 1k
Rz3_4_8 n3_4_8 n3_4_9 1k
Rg3_4_8 n3_4_8 0 50k
Rx3_4_9 n3_4_9 n4_4_9 1k
Ry3_4_9 n3_4_9 n3_5_9 1k
Rz3_4_9 n3_4_9 n3_4_10 1k
Rg3_4_9 n3_4_9 0 50k
Rx3_4_10 n3_4_10 n4_4_10 1k
Ry3_4_10 n3_4_10 n3_5_10 1k
Rg3_4_10 n3_4_10 0 50k
Rx3_5_0 n3_5_0 n4_5_0 1k
Ry3_5_0 n3_5_0 n3_6_0 1k
Rz3_5_0 n3_5_0 n3_5_1 1k
Rg3_5_0 n3_5_0 0 50k
Rx3_5_1 n3_5_1 n4_5_1 1k
Ry3_5_1 n3_5_1 n3_6_1 1k
Rz3_5_1 n3_5_1 n3_5_2 1k
Rg3_5_1 n3_5_1 0 50k
Rx3_5_2 n3_5_2 n4_5_2 1k
Ry3_5_2 n3_5_2 n3_6_2 1k
Rz3_5_2 n3_5_2 n3_5_3 1k
Rg3_5_2 n3_5_2 0 50k
Rx3_5_3 n3_5_3 n4_5_3 1k
Ry3_5_3 n3_5_3 n3_6_3 1k
Rz3_5_3 n3_5_3 n3_5_4 1k
Rg3_5_3 n3_5_3 0 50k
Rx3_5_4 n3_5_4 n4_5_4 1k
Ry3_5_4 n3_5_4 n3_6_4 1k
Rz3_5_4 n3_5_4 n3_5_5 1k
Rg3_5_4 n3_5_4 0 50k
Rx3_5_5 n3_5_5 n4_5_5 1k
Ry3_5_5 n3_5_5 n3_6_5 1k
Rz3_5_5 n3_5_5 n3_5_6 1k
Rg3_5_5 n3_5_5 0 50k
Rx3_5_6 n3_5_6 n4_5_6 1k
Ry3_5_6 n3_5_6 n3_6_6 1k
Rz3_5_6 n3_5_6 n3_5_7 1k
Rg3_5_6 n3_5_6 0 50k
Rx3_5_7 n3_5_7 n4_5_7 1k
Ry3_5_7 n3_5_7 n3_6_7 1k
Rz3_5_7 n3_5_7 n3_5_8 1k
Rg3_5_7 n3_5_7 0 50k
Rx3_5_8 n3_5_8 n4_5_8 1k
Ry3_5_8 n3_5_8 n3_6_8 1k
Rz3_5_8 n3_5_8 n3_5_9 1k
Rg3_5_8 n3_5_8 0 50k
Rx3_5_9 n3_5_9 n4_5_9 1k
Ry3_5_9 n3_5_9 n3_6_9 1k
Rz3_5_9 n3_5_9 n3_5_10 1k
Rg3_5_9 n3_5_9 0 50k
Rx3_5_10 n3_5_10 n4_5_10 1k
Ry3_5_10 n3_5_10 n3_6_10 1k
Rg3_5_10 n3_5_10 0 50k
Rx3_6_0 n3_6_0 n4_6_0 1k
Ry3_6_0 n3_6_0 n3_7_0 1k
Rz3_6_0 n3_6_0 n3_6_1 1k
Rg3_6_0 n3_6_0 0 50k
Rx3_6_1 n3_6_1 n4_6_1 1k
Ry3_6_1 n3_6_1 n3_7_1 1k
Rz3_6_1 n3_6_1 n3_6_2 1k
Rg3_6_1 n3_6_1 0 50k
Rx3_6_2 n3_6_2 n4_6_2 1k
Ry3_6_2 n3_6_2 n3_7_2 1k
Rz3_6_2 n3_6_2 n3_6_3 1k
Rg3_6_2 n3_6_2 0 50k
Rx3_6_3 n3_6_3 n4_6_3 1k
Ry3_6_3 n3_6_3 n3_7_3 1k
Rz3_6_3 n3_6_3 n3_6_4 1k
Rg3_6_3 n3_6_3 0 50k
Rx3_6_4 n3_6_4 n4_6_4 1k
Ry3_6_4 n3_6_4 n3_7_4 1k
Rz3_6_4 n3_6_4 n3_6_5 1k
Rg3_6_4 n3_6_4 0 50k
Rx3_6_5 n3_6_5 n4_6_5 1k
Ry3_6_5 n3_6_5 n3_7_5 1k
Rz3_6_5 n3_6_5 n3_6_6 1k
Rg3_6_5 n3_6_5 0 50k
Rx3_6_6 n3_6_6 n4_6_6 1k
Ry3_6_6 n3_6_6 n3_7_6 1k
Rz3_6_6 n3_6_6 n3_6_7 1k
Rg3_6_6 n3_6_6 0 50k
Rx3_6_7 n3_6_7 n4_6_7 1k
Ry3_6_7 n3_6_7 n3_7_7 1k
Rz3_6_7 n3_6_7 n3_6_8 1k
Rg3_6_7 n3_6_7 0 50k
Rx3_6_8 n3_6_8 n4_6_8 1k
Ry3_6_8 n3_6_8 n3_7_8 1k
Rz3_6_8 n3_6_8 n3_6_9 1k
Rg3_6_8 n3_6_8 0 50k
Rx3_6_9 n3_6_9 n4_6_9 1k
Ry3_6_9 n3_6_9 n3_7_9 1k
Rz3_6_9 n3_6_9 n3_6_10 1k
Rg3_6_9 n3_6_9 0 50k
Rx3_6_10 n3_6_10 n4_6_10 1k
Ry3_6_10 n3_6_10 n3_7_10 1k
Rg3_6_10 n3_6_10 0 50k
Rx3_7_0 n3_7_0 n4_7_0 1k
Ry3_7_0 n3_7_0 n3_8_0 1k
Rz3_7_0 n3_7_0 n3_7_1 1k
Rg3_7_0 n3_7_0 0 50k
Rx3_7_1 n3_7_1 n4_7_1 1k
Ry3_7_1 n3_7_1 n3_8_1 1k
Rz3_7_1 n3_7_1 n3_7_2 1k
Rg3_7_1 n3_7_1 0 50k
Rx3_7_2 n3_7_2 n4_7_2 1k
Ry3_7_2 n3_7_2 n3_8_2 1k
Rz3_7_2 n3_7_2 n3_7_3 1k
Rg3_7_2 n3_7_2 0 50k
Rx3_7_3 n3_7_3 n4_7_3 1k
Ry3_7_3 n3_7_3 n3_8_3 1k
Rz3_7_3 n3_7_3 n3_7_4 1k
Rg3_7_3 n3_7_3 0 50k
Rx3_7_4 n3_7_4 n4_7_4 1k
Ry3_7_4 n3_7_4 n3_8_4 1k
Rz3_7_4 n3_7_4 n3_7_5 1k
Rg3_7_4 n3_7_4 0 50k
Rx3_7_5 n3_7_5 n4_7_5 1k
Ry3_7_5 n3_7_5 n3_8_5 1k
Rz3_7_5 n3_7_5 n3_7_6 1k
Rg3_7_5 n3_7_5 0 50k
Rx3_7_6 n3_7_6 n4_7_6 1k
Ry3_7_6 n3_7_6 n3_8_6 1k
Rz3_7_6 n3_7_6 n3_7_7 1k
Rg3_7_6 n3_7_6 0 50k
Rx3_7_7 n3_7_7 n4_7_7 1k
Ry3_7_7 n3_7_7 n3_8_7 1k
Rz3_7_7 n3_7_7 n3_7_8 1k
Rg3_7_7 n3_7_7 0 50k
Rx3_7_8 n3_7_8 n4_7_8 1k
Ry3_7_8 n3_7_8 n3_8_8 1k
Rz3_7_8 n3_7_8 n3_7_9 1k
Rg3_7_8 n3_7_8 0 50k
Rx3_7_9 n3_7_9 n4_7_9 1k
Ry3_7_9 n3_7_9 n3_8_9 1k
Rz3_7_9 n3_7_9 n3_7_10 1k
Rg3_7_9 n3_7_9 0 50k
Rx3_7_10 n3_7_10 n4_7_10 1k
Ry3_7_10 n3_7_10 n3_8_10 1k
Rg3_7_10 n3_7_10 0 50k
Rx3_8_0 n3_8_0 n4_8_0 1k
Ry3_8_0 n3_8_0 n3_9_0 1k
Rz3_8_0 n3_8_0 n3_8_1 1k
Rg3_8_0 n3_8_0 0 50k
Rx3_8_1 n3_8_1 n4_8_1 1k
Ry3_8_1 n3_8_1 n3_9_1 1k
Rz3_8_1 n3_8_1 n3_8_2 1k
Rg3_8_1 n3_8_1 0 50k
Rx3_8_2 n3_8_2 n4_8_2 1k
Ry3_8_2 n3_8_2 n3_9_2 1k
Rz3_8_2 n3_8_2 n3_8_3 1k
Rg3_8_2 n3_8_2 0 50k
Rx3_8_3 n3_8_3 n4_8_3 1k
Ry3_8_3 n3_8_3 n3_9_3 1k
Rz3_8_3 n3_8_3 n3_8_4 1k
Rg3_8_3 n3_8_3 0 50k
Rx3_8_4 n3_8_4 n4_8_4 1k
Ry3_8_4 n3_8_4 n3_9_4 1k
Rz3_8_4 n3_8_4 n3_8_5 1k
Rg3_8_4 n3_8_4 0 50k
Rx3_8_5 n3_8_5 n4_8_5 1k
Ry3_8_5 n3_8_5 n3_9_5 1k
Rz3_8_5 n3_8_5 n3_8_6 1k
Rg3_8_5 n3_8_5 0 50k
Rx3_8_6 n3_8_6 n4_8_6 1k
Ry3_8_6 n3_8_6 n3_9_6 1k
Rz3_8_6 n3_8_6 n3_8_7 1k
Rg3_8_6 n3_8_6 0 50k
Rx3_8_7 n3_8_7 n4_8_7 1k
Ry3_8_7 n3_8_7 n3_9_7 1k
Rz3_8_7 n3_8_7 n3_8_8 1k
Rg3_8_7 n3_8_7 0 50k
Rx3_8_8 n3_8_8 n4_8_8 1k
Ry3_8_8 n3_8_8 n3_9_8 1k
Rz3_8_8 n3_8_8 n3_8_9 1k
Rg3_8_8 n3_8_8 0 50k
Rx3_8_9 n3_8_9 n4_8_9 1k
Ry3_8_9 n3_8_9 n3_9_9 1k
Rz3_8_9 n3_8_9 n3_8_10 1k
Rg3_8_9 n3_8_9 0 50k
Rx3_8_10 n3_8_10 n4_8_10 1k
Ry3_8_10 n3_8_10 n3_9_10 1k
Rg3_8_10 n3_8_10 0 50k
Rx3_9_0 n3_9_0 n4_9_0 1k
Ry3_9_0 n3_9_0 n3_10_0 1k
Rz3_9_0 n3_9_0 n3_9_1 1k
Rg3_9_0 n3_9_0 0 50k
Rx3_9_1 n3_9_1 n4_9_1 1k
Ry3_9_1 n3_9_1 n3_10_1 1k
Rz3_9_1 n3_9_1 n3_9_2 1k
Rg3_9_1 n3_9_1 0 50k
Rx3_9_2 n3_9_2 n4_9_2 1k
Ry3_9_2 n3_9_2 n3_10_2 1k
Rz3_9_2 n3_9_2 n3_9_3 1k
Rg3_9_2 n3_9_2 0 50k
Rx3_9_3 n3_9_3 n4_9_3 1k
Ry3_9_3 n3_9_3 n3_10_3 1k
Rz3_9_3 n3_9_3 n3_9_4 1k
Rg3_9_3 n3_9_3 0 50k
Rx3_9_4 n3_9_4 n4_9_4 1k
Ry3_9_4 n3_9_4 n3_10_4 1k
Rz3_9_4 n3_9_4 n3_9_5 1k
Rg3_9_4 n3_9_4 0 50k
Rx3_9_5 n3_9_5 n4_9_5 1k
Ry3_9_5 n3_9_5 n3_10_5 1k
Rz3_9_5 n3_9_5 n3_9_6 1k
Rg3_9_5 n3_9_5 0 50k
Rx3_9_6 n3_9_6 n4_9_6 1k
Ry3_9_6 n3_9_6 n3_10_6 1k
Rz3_9_6 n3_9_6 n3_9_7 1k
Rg3_9_6 n3_9_6 0 50k
Rx3_9_7 n3_9_7 n4_9_7 1k
Ry3_9_7 n3_9_7 n3_10_7 1k
Rz3_9_7 n3_9_7 n3_9_8 1k
Rg3_9_7 n3_9_7 0 50k
Rx3_9_8 n3_9_8 n4_9_8 1k
Ry3_9_8 n3_9_8 n3_10_8 1k
Rz3_9_8 n3_9_8 n3_9_9 1k
Rg3_9_8 n3_9_8 0 50k
Rx3_9_9 n3_9_9 n4_9_9 1k
Ry3_9_9 n3_9_9 n3_10_9 1k
Rz3_9_9 n3_9_9 n3_9_10 1k
Rg3_9_9 n3_9_9 0 50k
Rx3_9_10 n3_9_10 n4_9_10 1k
Ry3_9_10 n3_9_10 n3_10_10 1k
Rg3_9_10 n3_9_10 0 50k
Rx3_10_0 n3_10_0 n4_10_0 1k
Rz3_10_0 n3_10_0 n3_10_1 1k
Rg3_10_0 n3_10_0 0 50k
Rx3_10_1 n3_10_1 n4_10_1 1k
Rz3_10_1 n3_10_1 n3_10_2 1k
Rg3_10_1 n3_10_1 0 50k
Rx3_10_2 n3_10_2 n4_10_2 1k
Rz3_10_2 n3_10_2 n3_10_3 1k
Rg3_10_2 n3_10_2 0 50k
Rx3_10_3 n3_10_3 n4_10_3 1k
Rz3_10_3 n3_10_3 n3_10_4 1k
Rg3_10_3 n3_10_3 0 50k
Rx3_10_4 n3_10_4 n4_10_4 1k
Rz3_10_4 n3_10_4 n3_10_5 1k
Rg3_10_4 n3_10_4 0 50k
Rx3_10_5 n3_10_5 n4_10_5 1k
Rz3_10_5 n3_10_5 n3_10_6 1k
Rg3_10_5 n3_10_5 0 50k
Rx3_10_6 n3_10_6 n4_10_6 1k
Rz3_10_6 n3_10_6 n3_10_7 1k
Rg3_10_6 n3_10_6 0 50k
Rx3_10_7 n3_10_7 n4_10_7 1k
Rz3_10_7 n3_10_7 n3_10_8 1k
Rg3_10_7 n3_10_7 0 50k
Rx3_10_8 n3_10_8 n4_10_8 1k
Rz3_10_8 n3_10_8 n3_10_9 1k
Rg3_10_8 n3_10_8 0 50k
Rx3_10_9 n3_10_9 n4_10_9 1k
Rz3_10_9 n3_10_9 n3_10_10 1k
Rg3_10_9 n3_10_9 0 50k
Rx3_10_10 n3_10_10 n4_10_10 1k
Rg3_10_10 n3_10_10 0 50k
Rx4_0_0 n4_0_0 n5_0_0 1k
Ry4_0_0 n4_0_0 n4_1_0 1k
Rz4_0_0 n4_0_0 n4_0_1 1k
Rg4_0_0 n4_0_0 0 50k
Rx4_0_1 n4_0_1 n5_0_1 1k
Ry4_0_1 n4_0_1 n4_1_1 1k
Rz4_0_1 n4_0_1 n4_0_2 1k
Rg4_0_1 n4_0_1 0 50k
Rx4_0_2 n4_0_2 n5_0_2 1k
Ry4_0_2 n4_0_2 n4_1_2 1k
Rz4_0_2 n4_0_2 n4_0_3 1k
Rg4_0_2 n4_0_2 0 50k
Rx4_0_3 n4_0_3 n5_0_3 1k
Ry4_0_3 n4_0_3 n4_1_3 1k
Rz4_0_3 n4_0_3 n4_0_4 1k
Rg4_0_3 n4_0_3 0 50k
Rx4_0_4 n4_0_4 n5_0_4 1k
Ry4_0_4 n4_0_4 n4_1_4 1k
Rz4_0_4 n4_0_4 n4_0_5 1k
Rg4_0_4 n4_0_4 0 50k
Rx4_0_5 n4_0_5 n5_0_5 1k
Ry4_0_5 n4_0_5 n4_1_5 1k
Rz4_0_5 n4_0_5 n4_0_6 1k
Rg4_0_5 n4_0_5 0 50k
Rx4_0_6 n4_0_6 n5_0_6 1k
Ry4_0_6 n4_0_6 n4_1_6 1k
Rz4_0_6 n4_0_6 n4_0_7 1k
Rg4_0_6 n4_0_6 0 50k
Rx4_0_7 n4_0_7 n5_0_7 1k
Ry4_0_7 n4_0_7 n4_1_7 1k
Rz4_0_7 n4_0_7 n4_0_8 1k
Rg4_0_7 n4_0_7 0 50k
Rx4_0_8 n4_0_8 n5_0_8 1k
Ry4_0_8 n4_0_8 n4_1_8 1k
Rz4_0_8 n4_0_8 n4_0_9 1k
Rg4_0_8 n4_0_8 0 50k
Rx4_0_9 n4_0_9 n5_0_9 1k
Ry4_0_9 n4_0_9 n4_1_9 1k
Rz4_0_9 n4_0_9 n4_0_10 1k
Rg4_0_9 n4_0_9 0 50k
Rx4_0_10 n4_0_10 n5_0_10 1k
Ry4_0_10 n4_0_10 n4_1_10 1k
Rg4_0_10 n4_0_10 0 50k
Rx4_1_0 n4_1_0 n5_1_0 1k
Ry4_1_0 n4_1_0 n4_2_0 1k
Rz4_1_0 n4_1_0 n4_1_1 1k
Rg4_1_0 n4_1_0 0 50k
Rx4_1_1 n4_1_1 n5_1_1 1k
Ry4_1_1 n4_1_1 n4_2_1 1k
Rz4_1_1 n4_1_1 n4_1_2 1k
Rg4_1_1 n4_1_1 0 50k
Rx4_1_2 n4_1_2 n5_1_2 1k
Ry4_1_2 n4_1_2 n4_2_2 1k
Rz4_1_2 n4_1_2 n4_1_3 1k
Rg4_1_2 n4_1_2 0 50k
Rx4_1_3 n4_1_3 n5_1_3 1k
Ry4_1_3 n4_1_3 n4_2_3 1k
Rz4_1_3 n4_1_3 n4_1_4 1k
Rg4_1_3 n4_1_3 0 50k
Rx4_1_4 n4_1_4 n5_1_4 1k
Ry4_1_4 n4_1_4 n4_2_4 1k
Rz4_1_4 n4_1_4 n4_1_5 1k
Rg4_1_4 n4_1_4 0 50k
Rx4_1_5 n4_1_5 n5_1_5 1k
Ry4_1_5 n4_1_5 n4_2_5 1k
Rz4_1_5 n4_1_5 n4_1_6 1k
Rg4_1_5 n4_1_5 0 50k
Rx4_1_6 n4_1_6 n5_1_6 1k
Ry4_1_6 n4_1_6 n4_2_6 1k
Rz4_1_6 n4_1_6 n4_1_7 1k
Rg4_1_6 n4_1_6 0 50k
Rx4_1_7 n4_1_7 n5_1_7 1k
Ry4_1_7 n4_1_7 n4_2_7 1k
Rz4_1_7 n4_1_7 n4_1_8 1k
Rg4_1_7 n4_1_7 0 50k
Rx4_1_8 n4_1_8 n5_1_8 1k
Ry4_1_8 n4_1_8 n4_2_8 1k
Rz4_1_8 n4_1_8 n4_1_9 1k
Rg4_1_8 n4_1_8 0 50k
Rx4_1_9 n4_1_9 n5_1_9 1k
Ry4_1_9 n4_1_9 n4_2_9 1k
Rz4_1_9 n4_1_9 n4_1_10 1k
Rg4_1_9 n4_1_9 0 50k
Rx4_1_10 n4_1_10 n5_1_10 1k
Ry4_1_10 n4_1_10 n4_2_10 1k
Rg4_1_10 n4_1_10 0 50k
Rx4_2_0 n4_2_0 n5_2_0 1k
Ry4_2_0 n4_2_0 n4_3_0 1k
Rz4_2_0 n4_2_0 n4_2_1 1k
Rg4_2_0 n4_2_0 0 50k
Rx4_2_1 n4_2_1 n5_2_1 1k
Ry4_2_1 n4_2_1 n4_3_1 1k
Rz4_2_1 n4_2_1 n4_2_2 1k
Rg4_2_1 n4_2_1 0 50k
Rx4_2_2 n4_2_2 n5_2_2 1k
Ry4_2_2 n4_2_2 n4_3_2 1k
Rz4_2_2 n4_2_2 n4_2_3 1k
Rg4_2_2 n4_2_2 0 50k
Rx4_2_3 n4_2_3 n5_2_3 1k
Ry4_2_3 n4_2_3 n4_3_3 1k
Rz4_2_3 n4_2_3 n4_2_4 1k
Rg4_2_3 n4_2_3 0 50k
Rx4_2_4 n4_2_4 n5_2_4 1k
Ry4_2_4 n4_2_4 n4_3_4 1k
Rz4_2_4 n4_2_4 n4_2_5 1k
Rg4_2_4 n4_2_4 0 50k
Rx4_2_5 n4_2_5 n5_2_5 1k
Ry4_2_5 n4_2_5 n4_3_5 1k
Rz4_2_5 n4_2_5 n4_2_6 1k
Rg4_2_5 n4_2_5 0 50k
Rx4_2_6 n4_2_6 n5_2_6 1k
Ry4_2_6 n4_2_6 n4_3_6 1k
Rz4_2_6 n4_2_6 n4_2_7 1k
Rg4_2_6 n4_2_6 0 50k
Rx4_2_7 n4_2_7 n5_2_7 1k
Ry4_2_7 n4_2_7 n4_3_7 1k
Rz4_2_7 n4_2_7 n4_2_8 1k
Rg4_2_7 n4_2_7 0 50k
Rx4_2_8 n4_2_8 n5_2_8 1k
Ry4_2_8 n4_2_8 n4_3_8 1k
Rz4_2_8 n4_2_8 n4_2_9 1k
Rg4_2_8 n4_2_8 0 50k
Rx4_2_9 n4_2_9 n5_2_9 1k
Ry4_2_9 n4_2_9 n4_3_9 1k
Rz4_2_9 n4_2_9 n4_2_10 1k
Rg4_2_9 n4_2_9 0 50k
Rx4_2_10 n4_2_10 n5_2_10 1k
Ry4_2_10 n4_2_10 n4_3_10 1k
Rg4_2_10 n4_2_10 0 50k
Rx4_3_0 n4_3_0 n5_3_0 1k
Ry4_3_0 n4_3_0 n4_4_0 1k
Rz4_3_0 n4_3_0 n4_3_1 1k
Rg4_3_0 n4_3_0 0 50k
Rx4_3_1 n4_3_1 n5_3_1 1k
Ry4_3_1 n4_3_1 n4_4_1 1k
Rz4_3_1 n4_3_1 n4_3_2 1k
Rg4_3_1 n4_3_1 0 50k
Rx4_3_2 n4_3_2 n5_3_2 1k
Ry4_3_2 n4_3_2 n4_4_2 1k
Rz4_3_2 n4_3_2 n4_3_3 1k
Rg4_3_2 n4_3_2 0 50k
Rx4_3_3 n4_3_3 n5_3_3 1k
Ry4_3_3 n4_3_3 n4_4_3 1k
Rz4_3_3 n4_3_3 n4_3_4 1k
Rg4_3_3 n4_3_3 0 50k
Rx4_3_4 n4_3_4 n5_3_4 1k
Ry4_3_4 n4_3_4 n4_4_4 1k
Rz4_3_4 n4_3_4 n4_3_5 1k
Rg4_3_4 n4_3_4 0 50k
Rx4_3_5 n4_3_5 n5_3_5 1k
Ry4_3_5 n4_3_5 n4_4_5 1k
Rz4_3_5 n4_3_5 n4_3_6 1k
Rg4_3_5 n4_3_5 0 50k
Rx4_3_6 n4_3_6 n5_3_6 1k
Ry4_3_6 n4_3_6 n4_4_6 1k
Rz4_3_6 n4_3_6 n4_3_7 1k
Rg4_3_6 n4_3_6 0 50k
Rx4_3_7 n4_3_7 n5_3_7 1k
Ry4_3_7 n4_3_7 n4_4_7 1k
Rz4_3_7 n4_3_7 n4_3_8 1k
Rg4_3_7 n4_3_7 0 50k
Rx4_3_8 n4_3_8 n5_3_8 1k
Ry4_3_8 n4_3_8 n4_4_8 1k
Rz4_3_8 n4_3_8 n4_3_9 1k
Rg4_3_8 n4_3_8 0 50k
Rx4_3_9 n4_3_9 n5_3_9 1k
Ry4_3_9 n4_3_9 n4_4_9 1k
Rz4_3_9 n4_3_9 n4_3_10 1k
Rg4_3_9 n4_3_9 0 50k
Rx4_3_10 n4_3_10 n5_3_10 1k
Ry4_3_10 n4_3_10 n4_4_10 1k
Rg4_3_10 n4_3_10 0 50k
Rx4_4_0 n4_4_0 n5_4_0 1k
Ry4_4_0 n4_4_0 n4_5_0 1k
Rz4_4_0 n4_4_0 n4_4_1 1k
Rg4_4_0 n4_4_0 0 50k
Rx4_4_1 n4_4_1 n5_4_1 1k
Ry4_4_1 n4_4_1 n4_5_1 1k
Rz4_4_1 n4_4_1 n4_4_2 1k
Rg4_4_1 n4_4_1 0 50k
Rx4_4_2 n4_4_2 n5_4_2 1k
Ry4_4_2 n4_4_2 n4_5_2 1k
Rz4_4_2 n4_4_2 n4_4_3 1k
Rg4_4_2 n4_4_2 0 50k
Rx4_4_3 n4_4_3 n5_4_3 1k
Ry4_4_3 n4_4_3 n4_5_3 1k
Rz4_4_3 n4_4_3 n4_4_4 1k
Rg4_4_3 n4_4_3 0 50k
Rx4_4_4 n4_4_4 n5_4_4 1k
Ry4_4_4 n4_4_4 n4_5_4 1k
Rz4_4_4 n4_4_4 n4_4_5 1k
Rg4_4_4 n4_4_4 0 50k
Rx4_4_5 n4_4_5 n5_4_5 1k
Ry4_4_5 n4_4_5 n4_5_5 1k
Rz4_4_5 n4_4_5 n4_4_6 1k
Rg4_4_5 n4_4_5 0 50k
Rx4_4_6 n4_4_6 n5_4_6 1k
Ry4_4_6 n4_4_6 n4_5_6 1k
Rz4_4_6 n4_4_6 n4_4_7 1k
Rg4_4_6 n4_4_6 0 50k
Rx4_4_7 n4_4_7 n5_4_7 1k
Ry4_4_7 n4_4_7 n4_5_7 1k
Rz4_4_7 n4_4_7 n4_4_8 1k
Rg4_4_7 n4_4_7 0 50k
Rx4_4_8 n4_4_8 n5_4_8 1k
Ry4_4_8 n4_4_8 n4_5_8 1k
Rz4_4_8 n4_4_8 n4_4_9 1k
Rg4_4_8 n4_4_8 0 50k
Rx4_4_9 n4_4_9 n5_4_9 1k
Ry4_4_9 n4_4_9 n4_5_9 1k
Rz4_4_9 n4_4_9 n4_4_10 1k
Rg4_4_9 n4_4_9 0 50k
Rx4_4_10 n4_4_10 n5_4_10 1k
Ry4_4_10 n4_4_10 n4_5_10 1k
Rg4_4_10 n4_4_10 0 50k
Rx4_5_0 n4_5_0 n5_5_0 1k
Ry4_5_0 n4_5_0 n4_6_0 1k
Rz4_5_0 n4_5_0 n4_5_1 1k
Rg4_5_0 n4_5_0 0 50k
Rx4_5_1 n4_5_1 n5_5_1 1k
Ry4_5_1 n4_5_1 n4_6_1 1k
Rz4_5_1 n4_5_1 n4_5_2 1k
Rg4_5_1 n4_5_1 0 50k
Rx4_5_2 n4_5_2 n5_5_2 1k
Ry4_5_2 n4_5_2 n4_6_2 1k
Rz4_5_2 n4_5_2 n4_5_3 1k
Rg4_5_2 n4_5_2 0 50k
Rx4_5_3 n4_5_3 n5_5_3 1k
Ry4_5_3 n4_5_3 n4_6_3 1k
Rz4_5_3 n4_5_3 n4_5_4 1k
Rg4_5_3 n4_5_3 0 50k
Rx4_5_4 n4_5_4 n5_5_4 1k
Ry4_5_4 n4_5_4 n4_6_4 1k
Rz4_5_4 n4_5_4 n4_5_5 1k
Rg4_5_4 n4_5_4 0 50k
Rx4_5_5 n4_5_5 n5_5_5 1k
Ry4_5_5 n4_5_5 n4_6_5 1k
Rz4_5_5 n4_5_5 n4_5_6 1k
Rg4_5_5 n4_5_5 0 50k
Rx4_5_6 n4_5_6 n5_5_6 1k
Ry4_5_6 n4_5_6 n4_6_6 1k
Rz4_5_6 n4_5_6 n4_5_7 1k
Rg4_5_6 n4_5_6 0 50k
Rx4_5_7 n4_5_7 n5_5_7 1k
Ry4_5_7 n4_5_7 n4_6_7 1k
Rz4_5_7 n4_5_7 n4_5_8 1k
Rg4_5_7 n4_5_7 0 50k
Rx4_5_8 n4_5_8 n5_5_8 1k
Ry4_5_8 n4_5_8 n4_6_8 1k
Rz4_5_8 n4_5_8 n4_5_9 1k
Rg4_5_8 n4_5_8 0 50k
Rx4_5_9 n4_5_9 n5_5_9 1k
Ry4_5_9 n4_5_9 n4_6_9 1k
Rz4_5_9 n4_5_9 n4_5_10 1k
Rg4_5_9 n4_5_9 0 50k
Rx4_5_10 n4_5_10 n5_5_10 1k
Ry4_5_10 n4_5_10 n4_6_10 1k
Rg4_5_10 n4_5_10 0 50k
Rx4_6_0 n4_6_0 n5_6_0 1k
Ry4_6_0 n4_6_0 n4_7_0 1k
Rz4_6_0 n4_6_0 n4_6_1 1k
Rg4_6_0 n4_6_0 0 50k
Rx4_6_1 n4_6_1 n5_6_1 1k
Ry4_6_1 n4_6_1 n4_7_1 1k
Rz4_6_1 n4_6_1 n4_6_2 1k
Rg4_6_1 n4_6_1 0 50k
Rx4_6_2 n4_6_2 n5_6_2 1k
Ry4_6_2 n4_6_2 n4_7_2 1k
Rz4_6_2 n4_6_2 n4_6_3 1k
Rg4_6_2 n4_6_2 0 50k
Rx4_6_3 n4_6_3 n5_6_3 1k
Ry4_6_3 n4_6_3 n4_7_3 1k
Rz4_6_3 n4_6_3 n4_6_4 1k
Rg4_6_3 n4_6_3 0 50k
Rx4_6_4 n4_6_4 n5_6_4 1k
Ry4_6_4 n4_6_4 n4_7_4 1k
Rz4_6_4 n4_6_4 n4_6_5 1k
Rg4_6_4 n4_6_4 0 50k
Rx4_6_5 n4_6_5 n5_6_5 1k
Ry4_6_5 n4_6_5 n4_7_5 1k
Rz4_6_5 n4_6_5 n4_6_6 1k
Rg4_6_5 n4_6_5 0 50k
Rx4_6_6 n4_6_6 n5_6_6 1k
Ry4_6_6 n4_6_6 n4_7_6 1k
Rz4_6_6 n4_6_6 n4_6_7 1k
Rg4_6_6 n4_6_6 0 50k
Rx4_6_7 n4_6_7 n5_6_7 1k
Ry4_6_7 n4_6_7 n4_7_7 1k
Rz4_6_7 n4_6_7 n4_6_8 1k
Rg4_6_7 n4_6_7 0 50k
Rx4_6_8 n4_6_8 n5_6_8 1k
Ry4_6_8 n4_6_8 n4_7_8 1k
Rz4_6_8 n4_6_8 n4_6_9 1k
Rg4_6_8 n4_6_8 0 50k
Rx4_6_9 n4_6_9 n5_6_9 1k
Ry4_6_9 n4_6_9 n4_7_9 1k
Rz4_6_9 n4_6_9 n4_6_10 1k
Rg4_6_9 n4_6_9 0 50k
Rx4_6_10 n4_6_10 n5_6_10 1k
Ry4_6_10 n4_6_10 n4_7_10 1k
Rg4_6_10 n4_6_10 0 50k
Rx4_7_0 n4_7_0 n5_7_0 1k
Ry4_7_0 n4_7_0 n4_8_0 1k
Rz4_7_0 n4_7_0 n4_7_1 1k
Rg4_7_0 n4_7_0 0 50k
Rx4_7_1 n4_7_1 n5_7_1 1k
Ry4_7_1 n4_7_1 n4_8_1 1k
Rz4_7_1 n4_7_1 n4_7_2 1k
Rg4_7_1 n4_7_1 0 50k
Rx4_7_2 n4_7_2 n5_7_2 1k
Ry4_7_2 n4_7_2 n4_8_2 1k
Rz4_7_2 n4_7_2 n4_7_3 1k
Rg4_7_2 n4_7_2 0 50k
Rx4_7_3 n4_7_3 n5_7_3 1k
Ry4_7_3 n4_7_3 n4_8_3 1k
Rz4_7_3 n4_7_3 n4_7_4 1k
Rg4_7_3 n4_7_3 0 50k
Rx4_7_4 n4_7_4 n5_7_4 1k
Ry4_7_4 n4_7_4 n4_8_4 1k
Rz4_7_4 n4_7_4 n4_7_5 1k
Rg4_7_4 n4_7_4 0 50k
Rx4_7_5 n4_7_5 n5_7_5 1k
Ry4_7_5 n4_7_5 n4_8_5 1k
Rz4_7_5 n4_7_5 n4_7_6 1k
Rg4_7_5 n4_7_5 0 50k
Rx4_7_6 n4_7_6 n5_7_6 1k
Ry4_7_6 n4_7_6 n4_8_6 1k
Rz4_7_6 n4_7_6 n4_7_7 1k
Rg4_7_6 n4_7_6 0 50k
Rx4_7_7 n4_7_7 n5_7_7 1k
Ry4_7_7 n4_7_7 n4_8_7 1k
Rz4_7_7 n4_7_7 n4_7_8 1k
Rg4_7_7 n4_7_7 0 50k
Rx4_7_8 n4_7_8 n5_7_8 1k
Ry4_7_8 n4_7_8 n4_8_8 1k
Rz4_7_8 n4_7_8 n4_7_9 1k
Rg4_7_8 n4_7_8 0 50k
Rx4_7_9 n4_7_9 n5_7_9 1k
Ry4_7_9 n4_7_9 n4_8_9 1k
Rz4_7_9 n4_7_9 n4_7_10 1k
Rg4_7_9 n4_7_9 0 50k
Rx4_7_10 n4_7_10 n5_7_10 1k
Ry4_7_10 n4_7_10 n4_8_10 1k
Rg4_7_10 n4_7_10 0 50k
Rx4_8_0 n4_8_0 n5_8_0 1k
Ry4_8_0 n4_8_0 n4_9_0 1k
Rz4_8_0 n4_8_0 n4_8_1 1k
Rg4_8_0 n4_8_0 0 50k
Rx4_8_1 n4_8_1 n5_8_1 1k
Ry4_8_1 n4_8_1 n4_9_1 1k
Rz4_8_1 n4_8_1 n4_8_2 1k
Rg4_8_1 n4_8_1 0 50k
Rx4_8_2 n4_8_2 n5_8_2 1k
Ry4_8_2 n4_8_2 n4_9_2 1k
Rz4_8_2 n4_8_2 n4_8_3 1k
Rg4_8_2 n4_8_2 0 50k
Rx4_8_3 n4_8_3 n5_8_3 1k
Ry4_8_3 n4_8_3 n4_9_3 1k
Rz4_8_3 n4_8_3 n4_8_4 1k
Rg4_8_3 n4_8_3 0 50k
Rx4_8_4 n4_8_4 n5_8_4 1k
Ry4_8_4 n4_8_4 n4_9_4 1k
Rz4_8_4 n4_8_4 n4_8_5 1k
Rg4_8_4 n4_8_4 0 50k
Rx4_8_5 n4_8_5 n5_8_5 1k
Ry4_8_5 n4_8_5 n4_9_5 1k
Rz4_8_5 n4_8_5 n4_8_6 1k
Rg4_8_5 n4_8_5 0 50k
Rx4_8_6 n4_8_6 n5_8_6 1k
Ry4_8_6 n4_8_6 n4_9_6 1k
Rz4_8_6 n4_8_6 n4_8_7 1k
Rg4_8_6 n4_8_6 0 50k
Rx4_8_7 n4_8_7 n5_8_7 1k
Ry4_8_7 n4_8_7 n4_9_7 1k
Rz4_8_7 n4_8_7 n4_8_8 1k
Rg4_8_7 n4_8_7 0 50k
Rx4_8_8 n4_8_8 n5_8_8 1k
Ry4_8_8 n4_8_8 n4_9_8 1k
Rz4_8_8 n4_8_8 n4_8_9 1k
Rg4_8_8 n4_8_8 0 50k
Rx4_8_9 n4_8_9 n5_8_9 1k
Ry4_8_9 n4_8_9 n4_9_9 1k
Rz4_8_9 n4_8_9 n4_8_10 1k
Rg4_8_9 n4_8_9 0 50k
Rx4_8_10 n4_8_10 n5_8_10 1k
Ry4_8_10 n4_8_10 n4_9_10 1k
Rg4_8_10 n4_8_10 0 50k
Rx4_9_0 n4_9_0 n5_9_0 1k
Ry4_9_0 n4_9_0 n4_10_0 1k
Rz4_9_0 n4_9_0 n4_9_1 1k
Rg4_9_0 n4_9_0 0 50k
Rx4_9_1 n4_9_1 n5_9_1 1k
Ry4_9_1 n4_9_1 n4_10_1 1k
Rz4_9_1 n4_9_1 n4_9_2 1k
Rg4_9_1 n4_9_1 0 50k
Rx4_9_2 n4_9_2 n5_9_2 1k
Ry4_9_2 n4_9_2 n4_10_2 1k
Rz4_9_2 n4_9_2 n4_9_3 1k
Rg4_9_2 n4_9_2 0 50k
Rx4_9_3 n4_9_3 n5_9_3 1k
Ry4_9_3 n4_9_3 n4_10_3 1k
Rz4_9_3 n4_9_3 n4_9_4 1k
Rg4_9_3 n4_9_3 0 50k
Rx4_9_4 n4_9_4 n5_9_4 1k
Ry4_9_4 n4_9_4 n4_10_4 1k
Rz4_9_4 n4_9_4 n4_9_5 1k
Rg4_9_4 n4_9_4 0 50k
Rx4_9_5 n4_9_5 n5_9_5 1k
Ry4_9_5 n4_9_5 n4_10_5 1k
Rz4_9_5 n4_9_5 n4_9_6 1k
Rg4_9_5 n4_9_5 0 50k
Rx4_9_6 n4_9_6 n5_9_6 1k
Ry4_9_6 n4_9_6 n4_10_6 1k
Rz4_9_6 n4_9_6 n4_9_7 1k
Rg4_9_6 n4_9_6 0 50k
Rx4_9_7 n4_9_7 n5_9_7 1k
Ry4_9_7 n4_9_7 n4_10_7 1k
Rz4_9_7 n4_9_7 n4_9_8 1k
Rg4_9_7 n4_9_7 0 50k
Rx4_9_8 n4_9_8 n5_9_8 1k
Ry4_9_8 n4_9_8 n4_10_8 1k
Rz4_9_8 n4_9_8 n4_9_9 1k
Rg4_9_8 n4_9_8 0 50k
Rx4_9_9 n4_9_9 n5_9_9 1k
Ry4_9_9 n4_9_9 n4_10_9 1k
Rz4_9_9 n4_9_9 n4_9_10 1k
Rg4_9_9 n4_9_9 0 50k
Rx4_9_10 n4_9_10 n5_9_10 1k
Ry4_9_10 n4_9_10 n4_10_10 1k
Rg4_9_10 n4_9_10 0 50k
Rx4_10_0 n4_10_0 n5_10_0 1k
Rz4_10_0 n4_10_0 n4_10_1 1k
Rg4_10_0 n4_10_0 0 50k
Rx4_10_1 n4_10_1 n5_10_1 1k
Rz4_10_1 n4_10_1 n4_10_2 1k
Rg4_10_1 n4_10_1 0 50k
Rx4_10_2 n4_10_2 n5_10_2 1k
Rz4_10_2 n4_10_2 n4_10_3 1k
Rg4_10_2 n4_10_2 0 50k
Rx4_10_3 n4_10_3 n5_10_3 1k
Rz4_10_3 n4_10_3 n4_10_4 1k
Rg4_10_3 n4_10_3 0 50k
Rx4_10_4 n4_10_4 n5_10_4 1k
Rz4_10_4 n4_10_4 n4_10_5 1k
Rg4_10_4 n4_10_4 0 50k
Rx4_10_5 n4_10_5 n5_10_5 1k
Rz4_10_5 n4_10_5 n4_10_6 1k
Rg4_10_5 n4_10_5 0 50k
Rx4_10_6 n4_10_6 n5_10_6 1k
Rz4_10_6 n4_10_6 n4_10_7 1k
Rg4_10_6 n4_10_6 0 50k
Rx4_10_7 n4_10_7 n5_10_7 1k
Rz4_10_7 n4_10_7 n4_10_8 1k
Rg4_10_7 n4_10_7 0 50k
Rx4_10_8 n4_10_8 n5_10_8 1k
Rz4_10_8 n4_10_8 n4_10_9 1k
Rg4_10_8 n4_10_8 0 50k
Rx4_10_9 n4_10_9 n5_10_9 1k
Rz4_10_9 n4_10_9 n4_10_10 1k
Rg4_10_9 n4_10_9 0 50k
Rx4_10_10 n4_10_10 n5_10_10 1k
Rg4_10_10 n4_10_10 0 50k
Rx5_0_0 n5_0_0 n6_0_0 1k
Ry5_0_0 n5_0_0 n5_1_0 1k
Rz5_0_0 n5_0_0 n5_0_1 1k
Rg5_0_0 n5_0_0 0 50k
Rx5_0_1 n5_0_1 n6_0_1 1k
Ry5_0_1 n5_0_1 n5_1_1 1k
Rz5_0_1 n5_0_1 n5_0_2 1k
Rg5_0_1 n5_0_1 0 50k
Rx5_0_2 n5_0_2 n6_0_2 1k
Ry5_0_2 n5_0_2 n5_1_2 1k
Rz5_0_2 n5_0_2 n5_0_3 1k
Rg5_0_2 n5_0_2 0 50k
Rx5_0_3 n5_0_3 n6_0_3 1k
Ry5_0_3 n5_0_3 n5_1_3 1k
Rz5_0_3 n5_0_3 n5_0_4 1k
Rg5_0_3 n5_0_3 0 50k
Rx5_0_4 n5_0_4 n6_0_4 1k
Ry5_0_4 n5_0_4 n5_1_4 1k
Rz5_0_4 n5_0_4 n5_0_5 1k
Rg5_0_4 n5_0_4 0 50k
Rx5_0_5 n5_0_5 n6_0_5 1k
Ry5_0_5 n5_0_5 n5_1_5 1k
Rz5_0_5 n5_0_5 n5_0_6 1k
Rg5_0_5 n5_0_5 0 50k
Rx5_0_6 n5_0_6 n6_0_6 1k
Ry5_0_6 n5_0_6 n5_1_6 1k
Rz5_0_6 n5_0_6 n5_0_7 1k
Rg5_0_6 n5_0_6 0 50k
Rx5_0_7 n5_0_7 n6_0_7 1k
Ry5_0_7 n5_0_7 n5_1_7 1k
Rz5_0_7 n5_0_7 n5_0_8 1k
Rg5_0_7 n5_0_7 0 50k
Rx5_0_8 n5_0_8 n6_0_8 1k
Ry5_0_8 n5_0_8 n5_1_8 1k
Rz5_0_8 n5_0_8 n5_0_9 1k
Rg5_0_8 n5_0_8 0 50k
Rx5_0_9 n5_0_9 n6_0_9 1k
Ry5_0_9 n5_0_9 n5_1_9 1k
Rz5_0_9 n5_0_9 n5_0_10 1k
Rg5_0_9 n5_0_9 0 50k
Rx5_0_10 n5_0_10 n6_0_10 1k
Ry5_0_10 n5_0_10 n5_1_10 1k
Rg5_0_10 n5_0_10 0 50k
Rx5_1_0 n5_1_0 n6_1_0 1k
Ry5_1_0 n5_1_0 n5_2_0 1k
Rz5_1_0 n5_1_0 n5_1_1 1k
Rg5_1_0 n5_1_0 0 50k
Rx5_1_1 n5_1_1 n6_1_1 1k
Ry5_1_1 n5_1_1 n5_2_1 1k
Rz5_1_1 n5_1_1 n5_1_2 1k
Rg5_1_1 n5_1_1 0 50k
Rx5_1_2 n5_1_2 n6_1_2 1k
Ry5_1_2 n5_1_2 n5_2_2 1k
Rz5_1_2 n5_1_2 n5_1_3 1k
Rg5_1_2 n5_1_2 0 50k
Rx5_1_3 n5_1_3 n6_1_3 1k
Ry5_1_3 n5_1_3 n5_2_3 1k
Rz5_1_3 n5_1_3 n5_1_4 1k
Rg5_1_3 n5_1_3 0 50k
Rx5_1_4 n5_1_4 n6_1_4 1k
Ry5_1_4 n5_1_4 n5_2_4 1k
Rz5_1_4 n5_1_4 n5_1_5 1k
Rg5_1_4 n5_1_4 0 50k
Rx5_1_5 n5_1_5 n6_1_5 1k
Ry5_1_5 n5_1_5 n5_2_5 1k
Rz5_1_5 n5_1_5 n5_1_6 1k
Rg5_1_5 n5_1_5 0 50k
Rx5_1_6 n5_1_6 n6_1_6 1k
Ry5_1_6 n5_1_6 n5_2_6 1k
Rz5_1_6 n5_1_6 n5_1_7 1k
Rg5_1_6 n5_1_6 0 50k
Rx5_1_7 n5_1_7 n6_1_7 1k
Ry5_1_7 n5_1_7 n5_2_7 1k
Rz5_1_7 n5_1_7 n5_1_8 1k
Rg5_1_7 n5_1_7 0 50k
Rx5_1_8 n5_1_8 n6_1_8 1k
Ry5_1_8 n5_1_8 n5_2_8 1k
Rz5_1_8 n5_1_8 n5_1_9 1k
Rg5_1_8 n5_1_8 0 50k
Rx5_1_9 n5_1_9 n6_1_9 1k
Ry5_1_9 n5_1_9 n5_2_9 1k
Rz5_1_9 n5_1_9 n5_1_10 1k
Rg5_1_9 n5_1_9 0 50k
Rx5_1_10 n5_1_10 n6_1_10 1k
Ry5_1_10 n5_1_10 n5_2_10 1k
Rg5_1_10 n5_1_10 0 50k
Rx5_2_0 n5_2_0 n6_2_0 1k
Ry5_2_0 n5_2_0 n5_3_0 1k
Rz5_2_0 n5_2_0 n5_2_1 1k
Rg5_2_0 n5_2_0 0 50k
Rx5_2_1 n5_2_1 n6_2_1 1k
Ry5_2_1 n5_2_1 n5_3_1 1k
Rz5_2_1 n5_2_1 n5_2_2 1k
Rg5_2_1 n5_2_1 0 50k
Rx5_2_2 n5_2_2 n6_2_2 1k
Ry5_2_2 n5_2_2 n5_3_2 1k
Rz5_2_2 n5_2_2 n5_2_3 1k
Rg5_2_2 n5_2_2 0 50k
Rx5_2_3 n5_2_3 n6_2_3 1k
Ry5_2_3 n5_2_3 n5_3_3 1k
Rz5_2_3 n5_2_3 n5_2_4 1k
Rg5_2_3 n5_2_3 0 50k
Rx5_2_4 n5_2_4 n6_2_4 1k
Ry5_2_4 n5_2_4 n5_3_4 1k
Rz5_2_4 n5_2_4 n5_2_5 1k
Rg5_2_4 n5_2_4 0 50k
Rx5_2_5 n5_2_5 n6_2_5 1k
Ry5_2_5 n5_2_5 n5_3_5 1k
Rz5_2_5 n5_2_5 n5_2_6 1k
Rg5_2_5 n5_2_5 0 50k
Rx5_2_6 n5_2_6 n6_2_6 1k
Ry5_2_6 n5_2_6 n5_3_6 1k
Rz5_2_6 n5_2_6 n5_2_7 1k
Rg5_2_6 n5_2_6 0 50k
Rx5_2_7 n5_2_7 n6_2_7 1k
Ry5_2_7 n5_2_7 n5_3_7 1k
Rz5_2_7 n5_2_7 n5_2_8 1k
Rg5_2_7 n5_2_7 0 50k
Rx5_2_8 n5_2_8 n6_2_8 1k
Ry5_2_8 n5_2_8 n5_3_8 1k
Rz5_2_8 n5_2_8 n5_2_9 1k
Rg5_2_8 n5_2_8 0 50k
Rx5_2_9 n5_2_9 n6_2_9 1k
Ry5_2_9 n5_2_9 n5_3_9 1k
Rz5_2_9 n5_2_9 n5_2_10 1k
Rg5_2_9 n5_2_9 0 50k
Rx5_2_10 n5_2_10 n6_2_10 1k
Ry5_2_10 n5_2_10 n5_3_10 1k
Rg5_2_10 n5_2_10 0 50k
Rx5_3_0 n5_3_0 n6_3_0 1k
Ry5_3_0 n5_3_0 n5_4_0 1k
Rz5_3_0 n5_3_0 n5_3_1 1k
Rg5_3_0 n5_3_0 0 50k
Rx5_3_1 n5_3_1 n6_3_1 1k
Ry5_3_1 n5_3_1 n5_4_1 1k
Rz5_3_1 n5_3_1 n5_3_2 1k
Rg5_3_1 n5_3_1 0 50k
Rx5_3_2 n5_3_2 n6_3_2 1k
Ry5_3_2 n5_3_2 n5_4_2 1k
Rz5_3_2 n5_3_2 n5_3_3 1k
Rg5_3_2 n5_3_2 0 50k
Rx5_3_3 n5_3_3 n6_3_3 1k
Ry5_3_3 n5_3_3 n5_4_3 1k
Rz5_3_3 n5_3_3 n5_3_4 1k
Rg5_3_3 n5_3_3 0 50k
Rx5_3_4 n5_3_4 n6_3_4 1k
Ry5_3_4 n5_3_4 n5_4_4 1k
Rz5_3_4 n5_3_4 n5_3_5 1k
Rg5_3_4 n5_3_4 0 50k
Rx5_3_5 n5_3_5 n6_3_5 1k
Ry5_3_5 n5_3_5 n5_4_5 1k
Rz5_3_5 n5_3_5 n5_3_6 1k
Rg5_3_5 n5_3_5 0 50k
Rx5_3_6 n5_3_6 n6_3_6 1k
Ry5_3_6 n5_3_6 n5_4_6 1k
Rz5_3_6 n5_3_6 n5_3_7 1k
Rg5_3_6 n5_3_6 0 50k
Rx5_3_7 n5_3_7 n6_3_7 1k
Ry5_3_7 n5_3_7 n5_4_7 1k
Rz5_3_7 n5_3_7 n5_3_8 1k
Rg5_3_7 n5_3_7 0 50k
Rx5_3_8 n5_3_8 n6_3_8 1k
Ry5_3_8 n5_3_8 n5_4_8 1k
Rz5_3_8 n5_3_8 n5_3_9 1k
Rg5_3_8 n5_3_8 0 50k
Rx5_3_9 n5_3_9 n6_3_9 1k
Ry5_3_9 n5_3_9 n5_4_9 1k
Rz5_3_9 n5_3_9 n5_3_10 1k
Rg5_3_9 n5_3_9 0 50k
Rx5_3_10 n5_3_10 n6_3_10 1k
Ry5_3_10 n5_3_10 n5_4_10 1k
Rg5_3_10 n5_3_10 0 50k
Rx5_4_0 n5_4_0 n6_4_0 1k
Ry5_4_0 n5_4_0 n5_5_0 1k
Rz5_4_0 n5_4_0 n5_4_1 1k
Rg5_4_0 n5_4_0 0 50k
Rx5_4_1 n5_4_1 n6_4_1 1k
Ry5_4_1 n5_4_1 n5_5_1 1k
Rz5_4_1 n5_4_1 n5_4_2 1k
Rg5_4_1 n5_4_1 0 50k
Rx5_4_2 n5_4_2 n6_4_2 1k
Ry5_4_2 n5_4_2 n5_5_2 1k
Rz5_4_2 n5_4_2 n5_4_3 1k
Rg5_4_2 n5_4_2 0 50k
Rx5_4_3 n5_4_3 n6_4_3 1k
Ry5_4_3 n5_4_3 n5_5_3 1k
Rz5_4_3 n5_4_3 n5_4_4 1k
Rg5_4_3 n5_4_3 0 50k
Rx5_4_4 n5_4_4 n6_4_4 1k
Ry5_4_4 n5_4_4 n5_5_4 1k
Rz5_4_4 n5_4_4 n5_4_5 1k
Rg5_4_4 n5_4_4 0 50k
Rx5_4_5 n5_4_5 n6_4_5 1k
Ry5_4_5 n5_4_5 n5_5_5 1k
Rz5_4_5 n5_4_5 n5_4_6 1k
Rg5_4_5 n5_4_5 0 50k
Rx5_4_6 n5_4_6 n6_4_6 1k
Ry5_4_6 n5_4_6 n5_5_6 1k
Rz5_4_6 n5_4_6 n5_4_7 1k
Rg5_4_6 n5_4_6 0 50k
Rx5_4_7 n5_4_7 n6_4_7 1k
Ry5_4_7 n5_4_7 n5_5_7 1k
Rz5_4_7 n5_4_7 n5_4_8 1k
Rg5_4_7 n5_4_7 0 50k
Rx5_4_8 n5_4_8 n6_4_8 1k
Ry5_4_8 n5_4_8 n5_5_8 1k
Rz5_4_8 n5_4_8 n5_4_9 1k
Rg5_4_8 n5_4_8 0 50k
Rx5_4_9 n5_4_9 n6_4_9 1k
Ry5_4_9 n5_4_9 n5_5_9 1k
Rz5_4_9 n5_4_9 n5_4_10 1k
Rg5_4_9 n5_4_9 0 50k
Rx5_4_10 n5_4_10 n6_4_10 1k
Ry5_4_10 n5_4_10 n5_5_10 1k
Rg5_4_10 n5_4_10 0 50k
Rx5_5_0 n5_5_0 n6_5_0 1k
Ry5_5_0 n5_5_0 n5_6_0 1k
Rz5_5_0 n5_5_0 n5_5_1 1k
Rg5_5_0 n5_5_0 0 50k
Rx5_5_1 n5_5_1 n6_5_1 1k
Ry5_5_1 n5_5_1 n5_6_1 1k
Rz5_5_1 n5_5_1 n5_5_2 1k
Rg5_5_1 n5_5_1 0 50k
Rx5_5_2 n5_5_2 n6_5_2 1k
Ry5_5_2 n5_5_2 n5_6_2 1k
Rz5_5_2 n5_5_2 n5_5_3 1k
Rg5_5_2 n5_5_2 0 50k
Rx5_5_3 n5_5_3 n6_5_3 1k
Ry5_5_3 n5_5_3 n5_6_3 1k
Rz5_5_3 n5_5_3 n5_5_4 1k
Rg5_5_3 n5_5_3 0 50k
Rx5_5_4 n5_5_4 n6_5_4 1k
Ry5_5_4 n5_5_4 n5_6_4 1k
Rz5_5_4 n5_5_4 n5_5_5 1k
Rg5_5_4 n5_5_4 0 50k
Rx5_5_5 n5_5_5 n6_5_5 1k
Ry5_5_5 n5_5_5 n5_6_5 1k
Rz5_5_5 n5_5_5 n5_5_6 1k
Rg5_5_5 n5_5_5 0 50k
Rx5_5_6 n5_5_6 n6_5_6 1k
Ry5_5_6 n5_5_6 n5_6_6 1k
Rz5_5_6 n5_5_6 n5_5_7 1k
Rg5_5_6 n5_5_6 0 50k
Rx5_5_7 n5_5_7 n6_5_7 1k
Ry5_5_7 n5_5_7 n5_6_7 1k
Rz5_5_7 n5_5_7 n5_5_8 1k
Rg5_5_7 n5_5_7 0 50k
Rx5_5_8 n5_5_8 n6_5_8 1k
Ry5_5_8 n5_5_8 n5_6_8 1k
Rz5_5_8 n5_5_8 n5_5_9 1k
Rg5_5_8 n5_5_8 0 50k
Rx5_5_9 n5_5_9 n6_5_9 1k
Ry5_5_9 n5_5_9 n5_6_9 1k
Rz5_5_9 n5_5_9 n5_5_10 1k
Rg5_5_9 n5_5_9 0 50k
Rx5_5_10 n5_5_10 n6_5_10 1k
Ry5_5_10 n5_5_10 n5_6_10 1k
Rg5_5_10 n5_5_10 0 50k
Rx5_6_0 n5_6_0 n6_6_0 1k
Ry5_6_0 n5_6_0 n5_7_0 1k
Rz5_6_0 n5_6_0 n5_6_1 1k
Rg5_6_0 n5_6_0 0 50k
Rx5_6_1 n5_6_1 n6_6_1 1k
Ry5_6_1 n5_6_1 n5_7_1 1k
Rz5_6_1 n5_6_1 n5_6_2 1k
Rg5_6_1 n5_6_1 0 50k
Rx5_6_2 n5_6_2 n6_6_2 1k
Ry5_6_2 n5_6_2 n5_7_2 1k
Rz5_6_2 n5_6_2 n5_6_3 1k
Rg5_6_2 n5_6_2 0 50k
Rx5_6_3 n5_6_3 n6_6_3 1k
Ry5_6_3 n5_6_3 n5_7_3 1k
Rz5_6_3 n5_6_3 n5_6_4 1k
Rg5_6_3 n5_6_3 0 50k
Rx5_6_4 n5_6_4 n6_6_4 1k
Ry5_6_4 n5_6_4 n5_7_4 1k
Rz5_6_4 n5_6_4 n5_6_5 1k
Rg5_6_4 n5_6_4 0 50k
Rx5_6_5 n5_6_5 n6_6_5 1k
Ry5_6_5 n5_6_5 n5_7_5 1k
Rz5_6_5 n5_6_5 n5_6_6 1k
Rg5_6_5 n5_6_5 0 50k
Rx5_6_6 n5_6_6 n6_6_6 1k
Ry5_6_6 n5_6_6 n5_7_6 1k
Rz5_6_6 n5_6_6 n5_6_7 1k
Rg5_6_6 n5_6_6 0 50k
Rx5_6_7 n5_6_7 n6_6_7 1k
Ry5_6_7 n5_6_7 n5_7_7 1k
Rz5_6_7 n5_6_7 n5_6_8 1k
Rg5_6_7 n5_6_7 0 50k
Rx5_6_8 n5_6_8 n6_6_8 1k
Ry5_6_8 n5_6_8 n5_7_8 1k
Rz5_6_8 n5_6_8 n5_6_9 1k
Rg5_6_8 n5_6_8 0 50k
Rx5_6_9 n5_6_9 n6_6_9 1k
Ry5_6_9 n5_6_9 n5_7_9 1k
Rz5_6_9 n5_6_9 n5_6_10 1k
Rg5_6_9 n5_6_9 0 50k
Rx5_6_10 n5_6_10 n6_6_10 1k
Ry5_6_10 n5_6_10 n5_7_10 1k
Rg5_6_10 n5_6_10 0 50k
Rx5_7_0 n5_7_0 n6_7_0 1k
Ry5_7_0 n5_7_0 n5_8_0 1k
Rz5_7_0 n5_7_0 n5_7_1 1k
Rg5_7_0 n5_7_0 0 50k
Rx5_7_1 n5_7_1 n6_7_1 1k
Ry5_7_1 n5_7_1 n5_8_1 1k
Rz5_7_1 n5_7_1 n5_7_2 1k
Rg5_7_1 n5_7_1 0 50k
Rx5_7_2 n5_7_2 n6_7_2 1k
Ry5_7_2 n5_7_2 n5_8_2 1k
Rz5_7_2 n5_7_2 n5_7_3 1k
Rg5_7_2 n5_7_2 0 50k
Rx5_7_3 n5_7_3 n6_7_3 1k
Ry5_7_3 n5_7_3 n5_8_3 1k
Rz5_7_3 n5_7_3 n5_7_4 1k
Rg5_7_3 n5_7_3 0 50k
Rx5_7_4 n5_7_4 n6_7_4 1k
Ry5_7_4 n5_7_4 n5_8_4 1k
Rz5_7_4 n5_7_4 n5_7_5 1k
Rg5_7_4 n5_7_4 0 50k
Rx5_7_5 n5_7_5 n6_7_5 1k
Ry5_7_5 n5_7_5 n5_8_5 1k
Rz5_7_5 n5_7_5 n5_7_6 1k
Rg5_7_5 n5_7_5 0 50k
Rx5_7_6 n5_7_6 n6_7_6 1k
Ry5_7_6 n5_7_6 n5_8_6 1k
Rz5_7_6 n5_7_6 n5_7_7 1k
Rg5_7_6 n5_7_6 0 50k
Rx5_7_7 n5_7_7 n6_7_7 1k
Ry5_7_7 n5_7_7 n5_8_7 1k
Rz5_7_7 n5_7_7 n5_7_8 1k
Rg5_7_7 n5_7_7 0 50k
Rx5_7_8 n5_7_8 n6_7_8 1k
Ry5_7_8 n5_7_8 n5_8_8 1k
Rz5_7_8 n5_7_8 n5_7_9 1k
Rg5_7_8 n5_7_8 0 50k
Rx5_7_9 n5_7_9 n6_7_9 1k
Ry5_7_9 n5_7_9 n5_8_9 1k
Rz5_7_9 n5_7_9 n5_7_10 1k
Rg5_7_9 n5_7_9 0 50k
Rx5_7_10 n5_7_10 n6_7_10 1k
Ry5_7_10 n5_7_10 n5_8_10 1k
Rg5_7_10 n5_7_10 0 50k
Rx5_8_0 n5_8_0 n6_8_0 1k
Ry5_8_0 n5_8_0 n5_9_0 1k
Rz5_8_0 n5_8_0 n5_8_1 1k
Rg5_8_0 n5_8_0 0 50k
Rx5_8_1 n5_8_1 n6_8_1 1k
Ry5_8_1 n5_8_1 n5_9_1 1k
Rz5_8_1 n5_8_1 n5_8_2 1k
Rg5_8_1 n5_8_1 0 50k
Rx5_8_2 n5_8_2 n6_8_2 1k
Ry5_8_2 n5_8_2 n5_9_2 1k
Rz5_8_2 n5_8_2 n5_8_3 1k
Rg5_8_2 n5_8_2 0 50k
Rx5_8_3 n5_8_3 n6_8_3 1k
Ry5_8_3 n5_8_3 n5_9_3 1k
Rz5_8_3 n5_8_3 n5_8_4 1k
Rg5_8_3 n5_8_3 0 50k
Rx5_8_4 n5_8_4 n6_8_4 1k
Ry5_8_4 n5_8_4 n5_9_4 1k
Rz5_8_4 n5_8_4 n5_8_5 1k
Rg5_8_4 n5_8_4 0 50k
Rx5_8_5 n5_8_5 n6_8_5 1k
Ry5_8_5 n5_8_5 n5_9_5 1k
Rz5_8_5 n5_8_5 n5_8_6 1k
Rg5_8_5 n5_8_5 0 50k
Rx5_8_6 n5_8_6 n6_8_6 1k
Ry5_8_6 n5_8_6 n5_9_6 1k
Rz5_8_6 n5_8_6 n5_8_7 1k
Rg5_8_6 n5_8_6 0 50k
Rx5_8_7 n5_8_7 n6_8_7 1k
Ry5_8_7 n5_8_7 n5_9_7 1k
Rz5_8_7 n5_8_7 n5_8_8 1k
Rg5_8_7 n5_8_7 0 50k
Rx5_8_8 n5_8_8 n6_8_8 1k
Ry5_8_8 n5_8_8 n5_9_8 1k
Rz5_8_8 n5_8_8 n5_8_9 1k
Rg5_8_8 n5_8_8 0 50k
Rx5_8_9 n5_8_9 n6_8_9 1k
Ry5_8_9 n5_8_9 n5_9_9 1k
Rz5_8_9 n5_8_9 n5_8_10 1k
Rg5_8_9 n5_8_9 0 50k
Rx5_8_10 n5_8_10 n6_8_10 1k
Ry5_8_10 n5_8_10 n5_9_10 1k
Rg5_8_10 n5_8_10 0 50k
Rx5_9_0 n5_9_0 n6_9_0 1k
Ry5_9_0 n5_9_0 n5_10_0 1k
Rz5_9_0 n5_9_0 n5_9_1 1k
Rg5_9_0 n5_9_0 0 50k
Rx5_9_1 n5_9_1 n6_9_1 1k
Ry5_9_1 n5_9_1 n5_10_1 1k
Rz5_9_1 n5_9_1 n5_9_2 1k
Rg5_9_1 n5_9_1 0 50k
Rx5_9_2 n5_9_2 n6_9_2 1k
Ry5_9_2 n5_9_2 n5_10_2 1k
Rz5_9_2 n5_9_2 n5_9_3 1k
Rg5_9_2 n5_9_2 0 50k
Rx5_9_3 n5_9_3 n6_9_3 1k
Ry5_9_3 n5_9_3 n5_10_3 1k
Rz5_9_3 n5_9_3 n5_9_4 1k
Rg5_9_3 n5_9_3 0 50k
Rx5_9_4 n5_9_4 n6_9_4 1k
Ry5_9_4 n5_9_4 n5_10_4 1k
Rz5_9_4 n5_9_4 n5_9_5 1k
Rg5_9_4 n5_9_4 0 50k
Rx5_9_5 n5_9_5 n6_9_5 1k
Ry5_9_5 n5_9_5 n5_10_5 1k
Rz5_9_5 n5_9_5 n5_9_6 1k
Rg5_9_5 n5_9_5 0 50k
Rx5_9_6 n5_9_6 n6_9_6 1k
Ry5_9_6 n5_9_6 n5_10_6 1k
Rz5_9_6 n5_9_6 n5_9_7 1k
Rg5_9_6 n5_9_6 0 50k
Rx5_9_7 n5_9_7 n6_9_7 1k
Ry5_9_7 n5_9_7 n5_10_7 1k
Rz5_9_7 n5_9_7 n5_9_8 1k
Rg5_9_7 n5_9_7 0 50k
Rx5_9_8 n5_9_8 n6_9_8 1k
Ry5_9_8 n5_9_8 n5_10_8 1k
Rz5_9_8 n5_9_8 n5_9_9 1k
Rg5_9_8 n5_9_8 0 50k
Rx5_9_9 n5_9_9 n6_9_9 1k
Ry5_9_9 n5_9_9 n5_10_9 1k
Rz5_9_9 n5_9_9 n5_9_10 1k
Rg5_9_9 n5_9_9 0 50k
Rx5_9_10 n5_9_10 n6_9_10 1k
Ry5_9_10 n5_9_10 n5_10_10 1k
Rg5_9_10 n5_9_10 0 50k
Rx5_10_0 n5_10_0 n6_10_0 1k
Rz5_10_0 n5_10_0 n5_10_1 1k
Rg5_10_0 n5_10_0 0 50k
Rx5_10_1 n5_10_1 n6_10_1 1k
Rz5_10_1 n5_10_1 n5_10_2 1k
Rg5_10_1 n5_10_1 0 50k
Rx5_10_2 n5_10_2 n6_10_2 1k
Rz5_10_2 n5_10_2 n5_10_3 1k
Rg5_10_2 n5_10_2 0 50k
Rx5_10_3 n5_10_3 n6_10_3 1k
Rz5_10_3 n5_10_3 n5_10_4 1k
Rg5_10_3 n5_10_3 0 50k
Rx5_10_4 n5_10_4 n6_10_4 1k
Rz5_10_4 n5_10_4 n5_10_5 1k
Rg5_10_4 n5_10_4 0 50k
Rx5_10_5 n5_10_5 n6_10_5 1k
Rz5_10_5 n5_10_5 n5_10_6 1k
Rg5_10_5 n5_10_5 0 50k
Rx5_10_6 n5_10_6 n6_10_6 1k
Rz5_10_6 n5_10_6 n5_10_7 1k
Rg5_10_6 n5_10_6 0 50k
Rx5_10_7 n5_10_7 n6_10_7 1k
Rz5_10_7 n5_10_7 n5_10_8 1k
Rg5_10_7 n5_10_7 0 50k
Rx5_10_8 n5_10_8 n6_10_8 1k
Rz5_10_8 n5_10_8 n5_10_9 1k
Rg5_10_8 n5_10_8 0 50k
Rx5_10_9 n5_10_9 n6_10_9 1k
Rz5_10_9 n5_10_9 n5_10_10 1k
Rg5_10_9 n5_10_9 0 50k
Rx5_10_10 n5_10_10 n6_10_10 1k
Rg5_10_10 n5_10_10 0 50k
Rx6_0_0 n6_0_0 n7_0_0 1k
Ry6_0_0 n6_0_0 n6_1_0 1k
Rz6_0_0 n6_0_0 n6_0_1 1k
Rg6_0_0 n6_0_0 0 50k
Rx6_0_1 n6_0_1 n7_0_1 1k
Ry6_0_1 n6_0_1 n6_1_1 1k
Rz6_0_1 n6_0_1 n6_0_2 1k
Rg6_0_1 n6_0_1 0 50k
Rx6_0_2 n6_0_2 n7_0_2 1k
Ry6_0_2 n6_0_2 n6_1_2 1k
Rz6_0_2 n6_0_2 n6_0_3 1k
Rg6_0_2 n6_0_2 0 50k
Rx6_0_3 n6_0_3 n7_0_3 1k
Ry6_0_3 n6_0_3 n6_1_3 1k
Rz6_0_3 n6_0_3 n6_0_4 1k
Rg6_0_3 n6_0_3 0 50k
Rx6_0_4 n6_0_4 n7_0_4 1k
Ry6_0_4 n6_0_4 n6_1_4 1k
Rz6_0_4 n6_0_4 n6_0_5 1k
Rg6_0_4 n6_0_4 0 50k
Rx6_0_5 n6_0_5 n7_0_5 1k
Ry6_0_5 n6_0_5 n6_1_5 1k
Rz6_0_5 n6_0_5 n6_0_6 1k
Rg6_0_5 n6_0_5 0 50k
Rx6_0_6 n6_0_6 n7_0_6 1k
Ry6_0_6 n6_0_6 n6_1_6 1k
Rz6_0_6 n6_0_6 n6_0_7 1k
Rg6_0_6 n6_0_6 0 50k
Rx6_0_7 n6_0_7 n7_0_7 1k
Ry6_0_7 n6_0_7 n6_1_7 1k
Rz6_0_7 n6_0_7 n6_0_8 1k
Rg6_0_7 n6_0_7 0 50k
Rx6_0_8 n6_0_8 n7_0_8 1k
Ry6_0_8 n6_0_8 n6_1_8 1k
Rz6_0_8 n6_0_8 n6_0_9 1k
Rg6_0_8 n6_0_8 0 50k
Rx6_0_9 n6_0_9 n7_0_9 1k
Ry6_0_9 n6_0_9 n6_1_9 1k
Rz6_0_9 n6_0_9 n6_0_10 1k
Rg6_0_9 n6_0_9 0 50k
Rx6_0_10 n6_0_10 n7_0_10 1k
Ry6_0_10 n6_0_10 n6_1_10 1k
Rg6_0_10 n6_0_10 0 50k
Rx6_1_0 n6_1_0 n7_1_0 1k
Ry6_1_0 n6_1_0 n6_2_0 1k
Rz6_1_0 n6_1_0 n6_1_1 1k
Rg6_1_0 n6_1_0 0 50k
Rx6_1_1 n6_1_1 n7_1_1 1k
Ry6_1_1 n6_1_1 n6_2_1 1k
Rz6_1_1 n6_1_1 n6_1_2 1k
Rg6_1_1 n6_1_1 0 50k
Rx6_1_2 n6_1_2 n7_1_2 1k
Ry6_1_2 n6_1_2 n6_2_2 1k
Rz6_1_2 n6_1_2 n6_1_3 1k
Rg6_1_2 n6_1_2 0 50k
Rx6_1_3 n6_1_3 n7_1_3 1k
Ry6_1_3 n6_1_3 n6_2_3 1k
Rz6_1_3 n6_1_3 n6_1_4 1k
Rg6_1_3 n6_1_3 0 50k
Rx6_1_4 n6_1_4 n7_1_4 1k
Ry6_1_4 n6_1_4 n6_2_4 1k
Rz6_1_4 n6_1_4 n6_1_5 1k
Rg6_1_4 n6_1_4 0 50k
Rx6_1_5 n6_1_5 n7_1_5 1k
Ry6_1_5 n6_1_5 n6_2_5 1k
Rz6_1_5 n6_1_5 n6_1_6 1k
Rg6_1_5 n6_1_5 0 50k
Rx6_1_6 n6_1_6 n7_1_6 1k
Ry6_1_6 n6_1_6 n6_2_6 1k
Rz6_1_6 n6_1_6 n6_1_7 1k
Rg6_1_6 n6_1_6 0 50k
Rx6_1_7 n6_1_7 n7_1_7 1k
Ry6_1_7 n6_1_7 n6_2_7 1k
Rz6_1_7 n6_1_7 n6_1_8 1k
Rg6_1_7 n6_1_7 0 50k
Rx6_1_8 n6_1_8 n7_1_8 1k
Ry6_1_8 n6_1_8 n6_2_8 1k
Rz6_1_8 n6_1_8 n6_1_9 1k
Rg6_1_8 n6_1_8 0 50k
Rx6_1_9 n6_1_9 n7_1_9 1k
Ry6_1_9 n6_1_9 n6_2_9 1k
Rz6_1_9 n6_1_9 n6_1_10 1k
Rg6_1_9 n6_1_9 0 50k
Rx6_1_10 n6_1_10 n7_1_10 1k
Ry6_1_10 n6_1_10 n6_2_10 1k
Rg6_1_10 n6_1_10 0 50k
Rx6_2_0 n6_2_0 n7_2_0 1k
Ry6_2_0 n6_2_0 n6_3_0 1k
Rz6_2_0 n6_2_0 n6_2_1 1k
Rg6_2_0 n6_2_0 0 50k
Rx6_2_1 n6_2_1 n7_2_1 1k
Ry6_2_1 n6_2_1 n6_3_1 1k
Rz6_2_1 n6_2_1 n6_2_2 1k
Rg6_2_1 n6_2_1 0 50k
Rx6_2_2 n6_2_2 n7_2_2 1k
Ry6_2_2 n6_2_2 n6_3_2 1k
Rz6_2_2 n6_2_2 n6_2_3 1k
Rg6_2_2 n6_2_2 0 50k
Rx6_2_3 n6_2_3 n7_2_3 1k
Ry6_2_3 n6_2_3 n6_3_3 1k
Rz6_2_3 n6_2_3 n6_2_4 1k
Rg6_2_3 n6_2_3 0 50k
Rx6_2_4 n6_2_4 n7_2_4 1k
Ry6_2_4 n6_2_4 n6_3_4 1k
Rz6_2_4 n6_2_4 n6_2_5 1k
Rg6_2_4 n6_2_4 0 50k
Rx6_2_5 n6_2_5 n7_2_5 1k
Ry6_2_5 n6_2_5 n6_3_5 1k
Rz6_2_5 n6_2_5 n6_2_6 1k
Rg6_2_5 n6_2_5 0 50k
Rx6_2_6 n6_2_6 n7_2_6 1k
Ry6_2_6 n6_2_6 n6_3_6 1k
Rz6_2_6 n6_2_6 n6_2_7 1k
Rg6_2_6 n6_2_6 0 50k
Rx6_2_7 n6_2_7 n7_2_7 1k
Ry6_2_7 n6_2_7 n6_3_7 1k
Rz6_2_7 n6_2_7 n6_2_8 1k
Rg6_2_7 n6_2_7 0 50k
Rx6_2_8 n6_2_8 n7_2_8 1k
Ry6_2_8 n6_2_8 n6_3_8 1k
Rz6_2_8 n6_2_8 n6_2_9 1k
Rg6_2_8 n6_2_8 0 50k
Rx6_2_9 n6_2_9 n7_2_9 1k
Ry6_2_9 n6_2_9 n6_3_9 1k
Rz6_2_9 n6_2_9 n6_2_10 1k
Rg6_2_9 n6_2_9 0 50k
Rx6_2_10 n6_2_10 n7_2_10 1k
Ry6_2_10 n6_2_10 n6_3_10 1k
Rg6_2_10 n6_2_10 0 50k
Rx6_3_0 n6_3_0 n7_3_0 1k
Ry6_3_0 n6_3_0 n6_4_0 1k
Rz6_3_0 n6_3_0 n6_3_1 1k
Rg6_3_0 n6_3_0 0 50k
Rx6_3_1 n6_3_1 n7_3_1 1k
Ry6_3_1 n6_3_1 n6_4_1 1k
Rz6_3_1 n6_3_1 n6_3_2 1k
Rg6_3_1 n6_3_1 0 50k
Rx6_3_2 n6_3_2 n7_3_2 1k
Ry6_3_2 n6_3_2 n6_4_2 1k
Rz6_3_2 n6_3_2 n6_3_3 1k
Rg6_3_2 n6_3_2 0 50k
Rx6_3_3 n6_3_3 n7_3_3 1k
Ry6_3_3 n6_3_3 n6_4_3 1k
Rz6_3_3 n6_3_3 n6_3_4 1k
Rg6_3_3 n6_3_3 0 50k
Rx6_3_4 n6_3_4 n7_3_4 1k
Ry6_3_4 n6_3_4 n6_4_4 1k
Rz6_3_4 n6_3_4 n6_3_5 1k
Rg6_3_4 n6_3_4 0 50k
Rx6_3_5 n6_3_5 n7_3_5 1k
Ry6_3_5 n6_3_5 n6_4_5 1k
Rz6_3_5 n6_3_5 n6_3_6 1k
Rg6_3_5 n6_3_5 0 50k
Rx6_3_6 n6_3_6 n7_3_6 1k
Ry6_3_6 n6_3_6 n6_4_6 1k
Rz6_3_6 n6_3_6 n6_3_7 1k
Rg6_3_6 n6_3_6 0 50k
Rx6_3_7 n6_3_7 n7_3_7 1k
Ry6_3_7 n6_3_7 n6_4_7 1k
Rz6_3_7 n6_3_7 n6_3_8 1k
Rg6_3_7 n6_3_7 0 50k
Rx6_3_8 n6_3_8 n7_3_8 1k
Ry6_3_8 n6_3_8 n6_4_8 1k
Rz6_3_8 n6_3_8 n6_3_9 1k
Rg6_3_8 n6_3_8 0 50k
Rx6_3_9 n6_3_9 n7_3_9 1k
Ry6_3_9 n6_3_9 n6_4_9 1k
Rz6_3_9 n6_3_9 n6_3_10 1k
Rg6_3_9 n6_3_9 0 50k
Rx6_3_10 n6_3_10 n7_3_10 1k
Ry6_3_10 n6_3_10 n6_4_10 1k
Rg6_3_10 n6_3_10 0 50k
Rx6_4_0 n6_4_0 n7_4_0 1k
Ry6_4_0 n6_4_0 n6_5_0 1k
Rz6_4_0 n6_4_0 n6_4_1 1k
Rg6_4_0 n6_4_0 0 50k
Rx6_4_1 n6_4_1 n7_4_1 1k
Ry6_4_1 n6_4_1 n6_5_1 1k
Rz6_4_1 n6_4_1 n6_4_2 1k
Rg6_4_1 n6_4_1 0 50k
Rx6_4_2 n6_4_2 n7_4_2 1k
Ry6_4_2 n6_4_2 n6_5_2 1k
Rz6_4_2 n6_4_2 n6_4_3 1k
Rg6_4_2 n6_4_2 0 50k
Rx6_4_3 n6_4_3 n7_4_3 1k
Ry6_4_3 n6_4_3 n6_5_3 1k
Rz6_4_3 n6_4_3 n6_4_4 1k
Rg6_4_3 n6_4_3 0 50k
Rx6_4_4 n6_4_4 n7_4_4 1k
Ry6_4_4 n6_4_4 n6_5_4 1k
Rz6_4_4 n6_4_4 n6_4_5 1k
Rg6_4_4 n6_4_4 0 50k
Rx6_4_5 n6_4_5 n7_4_5 1k
Ry6_4_5 n6_4_5 n6_5_5 1k
Rz6_4_5 n6_4_5 n6_4_6 1k
Rg6_4_5 n6_4_5 0 50k
Rx6_4_6 n6_4_6 n7_4_6 1k
Ry6_4_6 n6_4_6 n6_5_6 1k
Rz6_4_6 n6_4_6 n6_4_7 1k
Rg6_4_6 n6_4_6 0 50k
Rx6_4_7 n6_4_7 n7_4_7 1k
Ry6_4_7 n6_4_7 n6_5_7 1k
Rz6_4_7 n6_4_7 n6_4_8 1k
Rg6_4_7 n6_4_7 0 50k
Rx6_4_8 n6_4_8 n7_4_8 1k
Ry6_4_8 n6_4_8 n6_5_8 1k
Rz6_4_8 n6_4_8 n6_4_9 1k
Rg6_4_8 n6_4_8 0 50k
Rx6_4_9 n6_4_9 n7_4_9 1k
Ry6_4_9 n6_4_9 n6_5_9 1k
Rz6_4_9 n6_4_9 n6_4_10 1k
Rg6_4_9 n6_4_9 0 50k
Rx6_4_10 n6_4_10 n7_4_10 1k
Ry6_4_10 n6_4_10 n6_5_10 1k
Rg6_4_10 n6_4_10 0 50k
Rx6_5_0 n6_5_0 n7_5_0 1k
Ry6_5_0 n6_5_0 n6_6_0 1k
Rz6_5_0 n6_5_0 n6_5_1 1k
Rg6_5_0 n6_5_0 0 50k
Rx6_5_1 n6_5_1 n7_5_1 1k
Ry6_5_1 n6_5_1 n6_6_1 1k
Rz6_5_1 n6_5_1 n6_5_2 1k
Rg6_5_1 n6_5_1 0 50k
Rx6_5_2 n6_5_2 n7_5_2 1k
Ry6_5_2 n6_5_2 n6_6_2 1k
Rz6_5_2 n6_5_2 n6_5_3 1k
Rg6_5_2 n6_5_2 0 50k
Rx6_5_3 n6_5_3 n7_5_3 1k
Ry6_5_3 n6_5_3 n6_6_3 1k
Rz6_5_3 n6_5_3 n6_5_4 1k
Rg6_5_3 n6_5_3 0 50k
Rx6_5_4 n6_5_4 n7_5_4 1k
Ry6_5_4 n6_5_4 n6_6_4 1k
Rz6_5_4 n6_5_4 n6_5_5 1k
Rg6_5_4 n6_5_4 0 50k
Rx6_5_5 n6_5_5 n7_5_5 1k
Ry6_5_5 n6_5_5 n6_6_5 1k
Rz6_5_5 n6_5_5 n6_5_6 1k
Rg6_5_5 n6_5_5 0 50k
Rx6_5_6 n6_5_6 n7_5_6 1k
Ry6_5_6 n6_5_6 n6_6_6 1k
Rz6_5_6 n6_5_6 n6_5_7 1k
Rg6_5_6 n6_5_6 0 50k
Rx6_5_7 n6_5_7 n7_5_7 1k
Ry6_5_7 n6_5_7 n6_6_7 1k
Rz6_5_7 n6_5_7 n6_5_8 1k
Rg6_5_7 n6_5_7 0 50k
Rx6_5_8 n6_5_8 n7_5_8 1k
Ry6_5_8 n6_5_8 n6_6_8 1k
Rz6_5_8 n6_5_8 n6_5_9 1k
Rg6_5_8 n6_5_8 0 50k
Rx6_5_9 n6_5_9 n7_5_9 1k
Ry6_5_9 n6_5_9 n6_6_9 1k
Rz6_5_9 n6_5_9 n6_5_10 1k
Rg6_5_9 n6_5_9 0 50k
Rx6_5_10 n6_5_10 n7_5_10 1k
Ry6_5_10 n6_5_10 n6_6_10 1k
Rg6_5_10 n6_5_10 0 50k
Rx6_6_0 n6_6_0 n7_6_0 1k
Ry6_6_0 n6_6_0 n6_7_0 1k
Rz6_6_0 n6_6_0 n6_6_1 1k
Rg6_6_0 n6_6_0 0 50k
Rx6_6_1 n6_6_1 n7_6_1 1k
Ry6_6_1 n6_6_1 n6_7_1 1k
Rz6_6_1 n6_6_1 n6_6_2 1k
Rg6_6_1 n6_6_1 0 50k
Rx6_6_2 n6_6_2 n7_6_2 1k
Ry6_6_2 n6_6_2 n6_7_2 1k
Rz6_6_2 n6_6_2 n6_6_3 1k
Rg6_6_2 n6_6_2 0 50k
Rx6_6_3 n6_6_3 n7_6_3 1k
Ry6_6_3 n6_6_3 n6_7_3 1k
Rz6_6_3 n6_6_3 n6_6_4 1k
Rg6_6_3 n6_6_3 0 50k
Rx6_6_4 n6_6_4 n7_6_4 1k
Ry6_6_4 n6_6_4 n6_7_4 1k
Rz6_6_4 n6_6_4 n6_6_5 1k
Rg6_6_4 n6_6_4 0 50k
Rx6_6_5 n6_6_5 n7_6_5 1k
Ry6_6_5 n6_6_5 n6_7_5 1k
Rz6_6_5 n6_6_5 n6_6_6 1k
Rg6_6_5 n6_6_5 0 50k
Rx6_6_6 n6_6_6 n7_6_6 1k
Ry6_6_6 n6_6_6 n6_7_6 1k
Rz6_6_6 n6_6_6 n6_6_7 1k
Rg6_6_6 n6_6_6 0 50k
Rx6_6_7 n6_6_7 n7_6_7 1k
Ry6_6_7 n6_6_7 n6_7_7 1k
Rz6_6_7 n6_6_7 n6_6_8 1k
Rg6_6_7 n6_6_7 0 50k
Rx6_6_8 n6_6_8 n7_6_8 1k
Ry6_6_8 n6_6_8 n6_7_8 1k
Rz6_6_8 n6_6_8 n6_6_9 1k
Rg6_6_8 n6_6_8 0 50k
Rx6_6_9 n6_6_9 n7_6_9 1k
Ry6_6_9 n6_6_9 n6_7_9 1k
Rz6_6_9 n6_6_9 n6_6_10 1k
Rg6_6_9 n6_6_9 0 50k
Rx6_6_10 n6_6_10 n7_6_10 1k
Ry6_6_10 n6_6_10 n6_7_10 1k
Rg6_6_10 n6_6_10 0 50k
Rx6_7_0 n6_7_0 n7_7_0 1k
Ry6_7_0 n6_7_0 n6_8_0 1k
Rz6_7_0 n6_7_0 n6_7_1 1k
Rg6_7_0 n6_7_0 0 50k
Rx6_7_1 n6_7_1 n7_7_1 1k
Ry6_7_1 n6_7_1 n6_8_1 1k
Rz6_7_1 n6_7_1 n6_7_2 1k
Rg6_7_1 n6_7_1 0 50k
Rx6_7_2 n6_7_2 n7_7_2 1k
Ry6_7_2 n6_7_2 n6_8_2 1k
Rz6_7_2 n6_7_2 n6_7_3 1k
Rg6_7_2 n6_7_2 0 50k
Rx6_7_3 n6_7_3 n7_7_3 1k
Ry6_7_3 n6_7_3 n6_8_3 1k
Rz6_7_3 n6_7_3 n6_7_4 1k
Rg6_7_3 n6_7_3 0 50k
Rx6_7_4 n6_7_4 n7_7_4 1k
Ry6_7_4 n6_7_4 n6_8_4 1k
Rz6_7_4 n6_7_4 n6_7_5 1k
Rg6_7_4 n6_7_4 0 50k
Rx6_7_5 n6_7_5 n7_7_5 1k
Ry6_7_5 n6_7_5 n6_8_5 1k
Rz6_7_5 n6_7_5 n6_7_6 1k
Rg6_7_5 n6_7_5 0 50k
Rx6_7_6 n6_7_6 n7_7_6 1k
Ry6_7_6 n6_7_6 n6_8_6 1k
Rz6_7_6 n6_7_6 n6_7_7 1k
Rg6_7_6 n6_7_6 0 50k
Rx6_7_7 n6_7_7 n7_7_7 1k
Ry6_7_7 n6_7_7 n6_8_7 1k
Rz6_7_7 n6_7_7 n6_7_8 1k
Rg6_7_7 n6_7_7 0 50k
Rx6_7_8 n6_7_8 n7_7_8 1k
Ry6_7_8 n6_7_8 n6_8_8 1k
Rz6_7_8 n6_7_8 n6_7_9 1k
Rg6_7_8 n6_7_8 0 50k
Rx6_7_9 n6_7_9 n7_7_9 1k
Ry6_7_9 n6_7_9 n6_8_9 1k
Rz6_7_9 n6_7_9 n6_7_10 1k
Rg6_7_9 n6_7_9 0 50k
Rx6_7_10 n6_7_10 n7_7_10 1k
Ry6_7_10 n6_7_10 n6_8_10 1k
Rg6_7_10 n6_7_10 0 50k
Rx6_8_0 n6_8_0 n7_8_0 1k
Ry6_8_0 n6_8_0 n6_9_0 1k
Rz6_8_0 n6_8_0 n6_8_1 1k
Rg6_8_0 n6_8_0 0 50k
Rx6_8_1 n6_8_1 n7_8_1 1k
Ry6_8_1 n6_8_1 n6_9_1 1k
Rz6_8_1 n6_8_1 n6_8_2 1k
Rg6_8_1 n6_8_1 0 50k
Rx6_8_2 n6_8_2 n7_8_2 1k
Ry6_8_2 n6_8_2 n6_9_2 1k
Rz6_8_2 n6_8_2 n6_8_3 1k
Rg6_8_2 n6_8_2 0 50k
Rx6_8_3 n6_8_3 n7_8_3 1k
Ry6_8_3 n6_8_3 n6_9_3 1k
Rz6_8_3 n6_8_3 n6_8_4 1k
Rg6_8_3 n6_8_3 0 50k
Rx6_8_4 n6_8_4 n7_8_4 1k
Ry6_8_4 n6_8_4 n6_9_4 1k
Rz6_8_4 n6_8_4 n6_8_5 1k
Rg6_8_4 n6_8_4 0 50k
Rx6_8_5 n6_8_5 n7_8_5 1k
Ry6_8_5 n6_8_5 n6_9_5 1k
Rz6_8_5 n6_8_5 n6_8_6 1k
Rg6_8_5 n6_8_5 0 50k
Rx6_8_6 n6_8_6 n7_8_6 1k
Ry6_8_6 n6_8_6 n6_9_6 1k
Rz6_8_6 n6_8_6 n6_8_7 1k
Rg6_8_6 n6_8_6 0 50k
Rx6_8_7 n6_8_7 n7_8_7 1k
Ry6_8_7 n6_8_7 n6_9_7 1k
Rz6_8_7 n6_8_7 n6_8_8 1k
Rg6_8_7 n6_8_7 0 50k
Rx6_8_8 n6_8_8 n7_8_8 1k
Ry6_8_8 n6_8_8 n6_9_8 1k
Rz6_8_8 n6_8_8 n6_8_9 1k
Rg6_8_8 n6_8_8 0 50k
Rx6_8_9 n6_8_9 n7_8_9 1k
Ry6_8_9 n6_8_9 n6_9_9 1k
Rz6_8_9 n6_8_9 n6_8_10 1k
Rg6_8_9 n6_8_9 0 50k
Rx6_8_10 n6_8_10 n7_8_10 1k
Ry6_8_10 n6_8_10 n6_9_10 1k
Rg6_8_10 n6_8_10 0 50k
Rx6_9_0 n6_9_0 n7_9_0 1k
Ry6_9_0 n6_9_0 n6_10_0 1k
Rz6_9_0 n6_9_0 n6_9_1 1k
Rg6_9_0 n6_9_0 0 50k
Rx6_9_1 n6_9_1 n7_9_1 1k
Ry6_9_1 n6_9_1 n6_10_1 1k
Rz6_9_1 n6_9_1 n6_9_2 1k
Rg6_9_1 n6_9_1 0 50k
Rx6_9_2 n6_9_2 n7_9_2 1k
Ry6_9_2 n6_9_2 n6_10_2 1k
Rz6_9_2 n6_9_2 n6_9_3 1k
Rg6_9_2 n6_9_2 0 50k
Rx6_9_3 n6_9_3 n7_9_3 1k
Ry6_9_3 n6_9_3 n6_10_3 1k
Rz6_9_3 n6_9_3 n6_9_4 1k
Rg6_9_3 n6_9_3 0 50k
Rx6_9_4 n6_9_4 n7_9_4 1k
Ry6_9_4 n6_9_4 n6_10_4 1k
Rz6_9_4 n6_9_4 n6_9_5 1k
Rg6_9_4 n6_9_4 0 50k
Rx6_9_5 n6_9_5 n7_9_5 1k
Ry6_9_5 n6_9_5 n6_10_5 1k
Rz6_9_5 n6_9_5 n6_9_6 1k
Rg6_9_5 n6_9_5 0 50k
Rx6_9_6 n6_9_6 n7_9_6 1k
Ry6_9_6 n6_9_6 n6_10_6 1k
Rz6_9_6 n6_9_6 n6_9_7 1k
Rg6_9_6 n6_9_6 0 50k
Rx6_9_7 n6_9_7 n7_9_7 1k
Ry6_9_7 n6_9_7 n6_10_7 1k
Rz6_9_7 n6_9_7 n6_9_8 1k
Rg6_9_7 n6_9_7 0 50k
Rx6_9_8 n6_9_8 n7_9_8 1k
Ry6_9_8 n6_9_8 n6_10_8 1k
Rz6_9_8 n6_9_8 n6_9_9 1k
Rg6_9_8 n6_9_8 0 50k
Rx6_9_9 n6_9_9 n7_9_9 1k
Ry6_9_9 n6_9_9 n6_10_9 1k
Rz6_9_9 n6_9_9 n6_9_10 1k
Rg6_9_9 n6_9_9 0 50k
Rx6_9_10 n6_9_10 n7_9_10 1k
Ry6_9_10 n6_9_10 n6_10_10 1k
Rg6_9_10 n6_9_10 0 50k
Rx6_10_0 n6_10_0 n7_10_0 1k
Rz6_10_0 n6_10_0 n6_10_1 1k
Rg6_10_0 n6_10_0 0 50k
Rx6_10_1 n6_10_1 n7_10_1 1k
Rz6_10_1 n6_10_1 n6_10_2 1k
Rg6_10_1 n6_10_1 0 50k
Rx6_10_2 n6_10_2 n7_10_2 1k
Rz6_10_2 n6_10_2 n6_10_3 1k
Rg6_10_2 n6_10_2 0 50k
Rx6_10_3 n6_10_3 n7_10_3 1k
Rz6_10_3 n6_10_3 n6_10_4 1k
Rg6_10_3 n6_10_3 0 50k
Rx6_10_4 n6_10_4 n7_10_4 1k
Rz6_10_4 n6_10_4 n6_10_5 1k
Rg6_10_4 n6_10_4 0 50k
Rx6_10_5 n6_10_5 n7_10_5 1k
Rz6_10_5 n6_10_5 n6_10_6 1k
Rg6_10_5 n6_10_5 0 50k
Rx6_10_6 n6_10_6 n7_10_6 1k
Rz6_10_6 n6_10_6 n6_10_7 1k
Rg6_10_6 n6_10_6 0 50k
Rx6_10_7 n6_10_7 n7_10_7 1k
Rz6_10_7 n6_10_7 n6_10_8 1k
Rg6_10_7 n6_10_7 0 50k
Rx6_10_8 n6_10_8 n7_10_8 1k
Rz6_10_8 n6_10_8 n6_10_9 1k
Rg6_10_8 n6_10_8 0 50k
Rx6_10_9 n6_10_9 n7_10_9 1k
Rz6_10_9 n6_10_9 n6_10_10 1k
Rg6_10_9 n6_10_9 0 50k
Rx6_10_10 n6_10_10 n7_10_10 1k
Rg6_10_10 n6_10_10 0 50k
Rx7_0_0 n7_0_0 n8_0_0 1k
Ry7_0_0 n7_0_0 n7_1_0 1k
Rz7_0_0 n7_0_0 n7_0_1 1k
Rg7_0_0 n7_0_0 0 50k
Rx7_0_1 n7_0_1 n8_0_1 1k
Ry7_0_1 n7_0_1 n7_1_1 1k
Rz7_0_1 n7_0_1 n7_0_2 1k
Rg7_0_1 n7_0_1 0 50k
Rx7_0_2 n7_0_2 n8_0_2 1k
Ry7_0_2 n7_0_2 n7_1_2 1k
Rz7_0_2 n7_0_2 n7_0_3 1k
Rg7_0_2 n7_0_2 0 50k
Rx7_0_3 n7_0_3 n8_0_3 1k
Ry7_0_3 n7_0_3 n7_1_3 1k
Rz7_0_3 n7_0_3 n7_0_4 1k
Rg7_0_3 n7_0_3 0 50k
Rx7_0_4 n7_0_4 n8_0_4 1k
Ry7_0_4 n7_0_4 n7_1_4 1k
Rz7_0_4 n7_0_4 n7_0_5 1k
Rg7_0_4 n7_0_4 0 50k
Rx7_0_5 n7_0_5 n8_0_5 1k
Ry7_0_5 n7_0_5 n7_1_5 1k
Rz7_0_5 n7_0_5 n7_0_6 1k
Rg7_0_5 n7_0_5 0 50k
Rx7_0_6 n7_0_6 n8_0_6 1k
Ry7_0_6 n7_0_6 n7_1_6 1k
Rz7_0_6 n7_0_6 n7_0_7 1k
Rg7_0_6 n7_0_6 0 50k
Rx7_0_7 n7_0_7 n8_0_7 1k
Ry7_0_7 n7_0_7 n7_1_7 1k
Rz7_0_7 n7_0_7 n7_0_8 1k
Rg7_0_7 n7_0_7 0 50k
Rx7_0_8 n7_0_8 n8_0_8 1k
Ry7_0_8 n7_0_8 n7_1_8 1k
Rz7_0_8 n7_0_8 n7_0_9 1k
Rg7_0_8 n7_0_8 0 50k
Rx7_0_9 n7_0_9 n8_0_9 1k
Ry7_0_9 n7_0_9 n7_1_9 1k
Rz7_0_9 n7_0_9 n7_0_10 1k
Rg7_0_9 n7_0_9 0 50k
Rx7_0_10 n7_0_10 n8_0_10 1k
Ry7_0_10 n7_0_10 n7_1_10 1k
Rg7_0_10 n7_0_10 0 50k
Rx7_1_0 n7_1_0 n8_1_0 1k
Ry7_1_0 n7_1_0 n7_2_0 1k
Rz7_1_0 n7_1_0 n7_1_1 1k
Rg7_1_0 n7_1_0 0 50k
Rx7_1_1 n7_1_1 n8_1_1 1k
Ry7_1_1 n7_1_1 n7_2_1 1k
Rz7_1_1 n7_1_1 n7_1_2 1k
Rg7_1_1 n7_1_1 0 50k
Rx7_1_2 n7_1_2 n8_1_2 1k
Ry7_1_2 n7_1_2 n7_2_2 1k
Rz7_1_2 n7_1_2 n7_1_3 1k
Rg7_1_2 n7_1_2 0 50k
Rx7_1_3 n7_1_3 n8_1_3 1k
Ry7_1_3 n7_1_3 n7_2_3 1k
Rz7_1_3 n7_1_3 n7_1_4 1k
Rg7_1_3 n7_1_3 0 50k
Rx7_1_4 n7_1_4 n8_1_4 1k
Ry7_1_4 n7_1_4 n7_2_4 1k
Rz7_1_4 n7_1_4 n7_1_5 1k
Rg7_1_4 n7_1_4 0 50k
Rx7_1_5 n7_1_5 n8_1_5 1k
Ry7_1_5 n7_1_5 n7_2_5 1k
Rz7_1_5 n7_1_5 n7_1_6 1k
Rg7_1_5 n7_1_5 0 50k
Rx7_1_6 n7_1_6 n8_1_6 1k
Ry7_1_6 n7_1_6 n7_2_6 1k
Rz7_1_6 n7_1_6 n7_1_7 1k
Rg7_1_6 n7_1_6 0 50k
Rx7_1_7 n7_1_7 n8_1_7 1k
Ry7_1_7 n7_1_7 n7_2_7 1k
Rz7_1_7 n7_1_7 n7_1_8 1k
Rg7_1_7 n7_1_7 0 50k
Rx7_1_8 n7_1_8 n8_1_8 1k
Ry7_1_8 n7_1_8 n7_2_8 1k
Rz7_1_8 n7_1_8 n7_1_9 1k
Rg7_1_8 n7_1_8 0 50k
Rx7_1_9 n7_1_9 n8_1_9 1k
Ry7_1_9 n7_1_9 n7_2_9 1k
Rz7_1_9 n7_1_9 n7_1_10 1k
Rg7_1_9 n7_1_9 0 50k
Rx7_1_10 n7_1_10 n8_1_10 1k
Ry7_1_10 n7_1_10 n7_2_10 1k
Rg7_1_10 n7_1_10 0 50k
Rx7_2_0 n7_2_0 n8_2_0 1k
Ry7_2_0 n7_2_0 n7_3_0 1k
Rz7_2_0 n7_2_0 n7_2_1 1k
Rg7_2_0 n7_2_0 0 50k
Rx7_2_1 n7_2_1 n8_2_1 1k
Ry7_2_1 n7_2_1 n7_3_1 1k
Rz7_2_1 n7_2_1 n7_2_2 1k
Rg7_2_1 n7_2_1 0 50k
Rx7_2_2 n7_2_2 n8_2_2 1k
Ry7_2_2 n7_2_2 n7_3_2 1k
Rz7_2_2 n7_2_2 n7_2_3 1k
Rg7_2_2 n7_2_2 0 50k
Rx7_2_3 n7_2_3 n8_2_3 1k
Ry7_2_3 n7_2_3 n7_3_3 1k
Rz7_2_3 n7_2_3 n7_2_4 1k
Rg7_2_3 n7_2_3 0 50k
Rx7_2_4 n7_2_4 n8_2_4 1k
Ry7_2_4 n7_2_4 n7_3_4 1k
Rz7_2_4 n7_2_4 n7_2_5 1k
Rg7_2_4 n7_2_4 0 50k
Rx7_2_5 n7_2_5 n8_2_5 1k
Ry7_2_5 n7_2_5 n7_3_5 1k
Rz7_2_5 n7_2_5 n7_2_6 1k
Rg7_2_5 n7_2_5 0 50k
Rx7_2_6 n7_2_6 n8_2_6 1k
Ry7_2_6 n7_2_6 n7_3_6 1k
Rz7_2_6 n7_2_6 n7_2_7 1k
Rg7_2_6 n7_2_6 0 50k
Rx7_2_7 n7_2_7 n8_2_7 1k
Ry7_2_7 n7_2_7 n7_3_7 1k
Rz7_2_7 n7_2_7 n7_2_8 1k
Rg7_2_7 n7_2_7 0 50k
Rx7_2_8 n7_2_8 n8_2_8 1k
Ry7_2_8 n7_2_8 n7_3_8 1k
Rz7_2_8 n7_2_8 n7_2_9 1k
Rg7_2_8 n7_2_8 0 50k
Rx7_2_9 n7_2_9 n8_2_9 1k
Ry7_2_9 n7_2_9 n7_3_9 1k
Rz7_2_9 n7_2_9 n7_2_10 1k
Rg7_2_9 n7_2_9 0 50k
Rx7_2_10 n7_2_10 n8_2_10 1k
Ry7_2_10 n7_2_10 n7_3_10 1k
Rg7_2_10 n7_2_10 0 50k
Rx7_3_0 n7_3_0 n8_3_0 1k
Ry7_3_0 n7_3_0 n7_4_0 1k
Rz7_3_0 n7_3_0 n7_3_1 1k
Rg7_3_0 n7_3_0 0 50k
Rx7_3_1 n7_3_1 n8_3_1 1k
Ry7_3_1 n7_3_1 n7_4_1 1k
Rz7_3_1 n7_3_1 n7_3_2 1k
Rg7_3_1 n7_3_1 0 50k
Rx7_3_2 n7_3_2 n8_3_2 1k
Ry7_3_2 n7_3_2 n7_4_2 1k
Rz7_3_2 n7_3_2 n7_3_3 1k
Rg7_3_2 n7_3_2 0 50k
Rx7_3_3 n7_3_3 n8_3_3 1k
Ry7_3_3 n7_3_3 n7_4_3 1k
Rz7_3_3 n7_3_3 n7_3_4 1k
Rg7_3_3 n7_3_3 0 50k
Rx7_3_4 n7_3_4 n8_3_4 1k
Ry7_3_4 n7_3_4 n7_4_4 1k
Rz7_3_4 n7_3_4 n7_3_5 1k
Rg7_3_4 n7_3_4 0 50k
Rx7_3_5 n7_3_5 n8_3_5 1k
Ry7_3_5 n7_3_5 n7_4_5 1k
Rz7_3_5 n7_3_5 n7_3_6 1k
Rg7_3_5 n7_3_5 0 50k
Rx7_3_6 n7_3_6 n8_3_6 1k
Ry7_3_6 n7_3_6 n7_4_6 1k
Rz7_3_6 n7_3_6 n7_3_7 1k
Rg7_3_6 n7_3_6 0 50k
Rx7_3_7 n7_3_7 n8_3_7 1k
Ry7_3_7 n7_3_7 n7_4_7 1k
Rz7_3_7 n7_3_7 n7_3_8 1k
Rg7_3_7 n7_3_7 0 50k
Rx7_3_8 n7_3_8 n8_3_8 1k
Ry7_3_8 n7_3_8 n7_4_8 1k
Rz7_3_8 n7_3_8 n7_3_9 1k
Rg7_3_8 n7_3_8 0 50k
Rx7_3_9 n7_3_9 n8_3_9 1k
Ry7_3_9 n7_3_9 n7_4_9 1k
Rz7_3_9 n7_3_9 n7_3_10 1k
Rg7_3_9 n7_3_9 0 50k
Rx7_3_10 n7_3_10 n8_3_10 1k
Ry7_3_10 n7_3_10 n7_4_10 1k
Rg7_3_10 n7_3_10 0 50k
Rx7_4_0 n7_4_0 n8_4_0 1k
Ry7_4_0 n7_4_0 n7_5_0 1k
Rz7_4_0 n7_4_0 n7_4_1 1k
Rg7_4_0 n7_4_0 0 50k
Rx7_4_1 n7_4_1 n8_4_1 1k
Ry7_4_1 n7_4_1 n7_5_1 1k
Rz7_4_1 n7_4_1 n7_4_2 1k
Rg7_4_1 n7_4_1 0 50k
Rx7_4_2 n7_4_2 n8_4_2 1k
Ry7_4_2 n7_4_2 n7_5_2 1k
Rz7_4_2 n7_4_2 n7_4_3 1k
Rg7_4_2 n7_4_2 0 50k
Rx7_4_3 n7_4_3 n8_4_3 1k
Ry7_4_3 n7_4_3 n7_5_3 1k
Rz7_4_3 n7_4_3 n7_4_4 1k
Rg7_4_3 n7_4_3 0 50k
Rx7_4_4 n7_4_4 n8_4_4 1k
Ry7_4_4 n7_4_4 n7_5_4 1k
Rz7_4_4 n7_4_4 n7_4_5 1k
Rg7_4_4 n7_4_4 0 50k
Rx7_4_5 n7_4_5 n8_4_5 1k
Ry7_4_5 n7_4_5 n7_5_5 1k
Rz7_4_5 n7_4_5 n7_4_6 1k
Rg7_4_5 n7_4_5 0 50k
Rx7_4_6 n7_4_6 n8_4_6 1k
Ry7_4_6 n7_4_6 n7_5_6 1k
Rz7_4_6 n7_4_6 n7_4_7 1k
Rg7_4_6 n7_4_6 0 50k
Rx7_4_7 n7_4_7 n8_4_7 1k
Ry7_4_7 n7_4_7 n7_5_7 1k
Rz7_4_7 n7_4_7 n7_4_8 1k
Rg7_4_7 n7_4_7 0 50k
Rx7_4_8 n7_4_8 n8_4_8 1k
Ry7_4_8 n7_4_8 n7_5_8 1k
Rz7_4_8 n7_4_8 n7_4_9 1k
Rg7_4_8 n7_4_8 0 50k
Rx7_4_9 n7_4_9 n8_4_9 1k
Ry7_4_9 n7_4_9 n7_5_9 1k
Rz7_4_9 n7_4_9 n7_4_10 1k
Rg7_4_9 n7_4_9 0 50k
Rx7_4_10 n7_4_10 n8_4_10 1k
Ry7_4_10 n7_4_10 n7_5_10 1k
Rg7_4_10 n7_4_10 0 50k
Rx7_5_0 n7_5_0 n8_5_0 1k
Ry7_5_0 n7_5_0 n7_6_0 1k
Rz7_5_0 n7_5_0 n7_5_1 1k
Rg7_5_0 n7_5_0 0 50k
Rx7_5_1 n7_5_1 n8_5_1 1k
Ry7_5_1 n7_5_1 n7_6_1 1k
Rz7_5_1 n7_5_1 n7_5_2 1k
Rg7_5_1 n7_5_1 0 50k
Rx7_5_2 n7_5_2 n8_5_2 1k
Ry7_5_2 n7_5_2 n7_6_2 1k
Rz7_5_2 n7_5_2 n7_5_3 1k
Rg7_5_2 n7_5_2 0 50k
Rx7_5_3 n7_5_3 n8_5_3 1k
Ry7_5_3 n7_5_3 n7_6_3 1k
Rz7_5_3 n7_5_3 n7_5_4 1k
Rg7_5_3 n7_5_3 0 50k
Rx7_5_4 n7_5_4 n8_5_4 1k
Ry7_5_4 n7_5_4 n7_6_4 1k
Rz7_5_4 n7_5_4 n7_5_5 1k
Rg7_5_4 n7_5_4 0 50k
Rx7_5_5 n7_5_5 n8_5_5 1k
Ry7_5_5 n7_5_5 n7_6_5 1k
Rz7_5_5 n7_5_5 n7_5_6 1k
Rg7_5_5 n7_5_5 0 50k
Rx7_5_6 n7_5_6 n8_5_6 1k
Ry7_5_6 n7_5_6 n7_6_6 1k
Rz7_5_6 n7_5_6 n7_5_7 1k
Rg7_5_6 n7_5_6 0 50k
Rx7_5_7 n7_5_7 n8_5_7 1k
Ry7_5_7 n7_5_7 n7_6_7 1k
Rz7_5_7 n7_5_7 n7_5_8 1k
Rg7_5_7 n7_5_7 0 50k
Rx7_5_8 n7_5_8 n8_5_8 1k
Ry7_5_8 n7_5_8 n7_6_8 1k
Rz7_5_8 n7_5_8 n7_5_9 1k
Rg7_5_8 n7_5_8 0 50k
Rx7_5_9 n7_5_9 n8_5_9 1k
Ry7_5_9 n7_5_9 n7_6_9 1k
Rz7_5_9 n7_5_9 n7_5_10 1k
Rg7_5_9 n7_5_9 0 50k
Rx7_5_10 n7_5_10 n8_5_10 1k
Ry7_5_10 n7_5_10 n7_6_10 1k
Rg7_5_10 n7_5_10 0 50k
Rx7_6_0 n7_6_0 n8_6_0 1k
Ry7_6_0 n7_6_0 n7_7_0 1k
Rz7_6_0 n7_6_0 n7_6_1 1k
Rg7_6_0 n7_6_0 0 50k
Rx7_6_1 n7_6_1 n8_6_1 1k
Ry7_6_1 n7_6_1 n7_7_1 1k
Rz7_6_1 n7_6_1 n7_6_2 1k
Rg7_6_1 n7_6_1 0 50k
Rx7_6_2 n7_6_2 n8_6_2 1k
Ry7_6_2 n7_6_2 n7_7_2 1k
Rz7_6_2 n7_6_2 n7_6_3 1k
Rg7_6_2 n7_6_2 0 50k
Rx7_6_3 n7_6_3 n8_6_3 1k
Ry7_6_3 n7_6_3 n7_7_3 1k
Rz7_6_3 n7_6_3 n7_6_4 1k
Rg7_6_3 n7_6_3 0 50k
Rx7_6_4 n7_6_4 n8_6_4 1k
Ry7_6_4 n7_6_4 n7_7_4 1k
Rz7_6_4 n7_6_4 n7_6_5 1k
Rg7_6_4 n7_6_4 0 50k
Rx7_6_5 n7_6_5 n8_6_5 1k
Ry7_6_5 n7_6_5 n7_7_5 1k
Rz7_6_5 n7_6_5 n7_6_6 1k
Rg7_6_5 n7_6_5 0 50k
Rx7_6_6 n7_6_6 n8_6_6 1k
Ry7_6_6 n7_6_6 n7_7_6 1k
Rz7_6_6 n7_6_6 n7_6_7 1k
Rg7_6_6 n7_6_6 0 50k
Rx7_6_7 n7_6_7 n8_6_7 1k
Ry7_6_7 n7_6_7 n7_7_7 1k
Rz7_6_7 n7_6_7 n7_6_8 1k
Rg7_6_7 n7_6_7 0 50k
Rx7_6_8 n7_6_8 n8_6_8 1k
Ry7_6_8 n7_6_8 n7_7_8 1k
Rz7_6_8 n7_6_8 n7_6_9 1k
Rg7_6_8 n7_6_8 0 50k
Rx7_6_9 n7_6_9 n8_6_9 1k
Ry7_6_9 n7_6_9 n7_7_9 1k
Rz7_6_9 n7_6_9 n7_6_10 1k
Rg7_6_9 n7_6_9 0 50k
Rx7_6_10 n7_6_10 n8_6_10 1k
Ry7_6_10 n7_6_10 n7_7_10 1k
Rg7_6_10 n7_6_10 0 50k
Rx7_7_0 n7_7_0 n8_7_0 1k
Ry7_7_0 n7_7_0 n7_8_0 1k
Rz7_7_0 n7_7_0 n7_7_1 1k
Rg7_7_0 n7_7_0 0 50k
Rx7_7_1 n7_7_1 n8_7_1 1k
Ry7_7_1 n7_7_1 n7_8_1 1k
Rz7_7_1 n7_7_1 n7_7_2 1k
Rg7_7_1 n7_7_1 0 50k
Rx7_7_2 n7_7_2 n8_7_2 1k
Ry7_7_2 n7_7_2 n7_8_2 1k
Rz7_7_2 n7_7_2 n7_7_3 1k
Rg7_7_2 n7_7_2 0 50k
Rx7_7_3 n7_7_3 n8_7_3 1k
Ry7_7_3 n7_7_3 n7_8_3 1k
Rz7_7_3 n7_7_3 n7_7_4 1k
Rg7_7_3 n7_7_3 0 50k
Rx7_7_4 n7_7_4 n8_7_4 1k
Ry7_7_4 n7_7_4 n7_8_4 1k
Rz7_7_4 n7_7_4 n7_7_5 1k
Rg7_7_4 n7_7_4 0 50k
Rx7_7_5 n7_7_5 n8_7_5 1k
Ry7_7_5 n7_7_5 n7_8_5 1k
Rz7_7_5 n7_7_5 n7_7_6 1k
Rg7_7_5 n7_7_5 0 50k
Rx7_7_6 n7_7_6 n8_7_6 1k
Ry7_7_6 n7_7_6 n7_8_6 1k
Rz7_7_6 n7_7_6 n7_7_7 1k
Rg7_7_6 n7_7_6 0 50k
Rx7_7_7 n7_7_7 n8_7_7 1k
Ry7_7_7 n7_7_7 n7_8_7 1k
Rz7_7_7 n7_7_7 n7_7_8 1k
Rg7_7_7 n7_7_7 0 50k
Rx7_7_8 n7_7_8 n8_7_8 1k
Ry7_7_8 n7_7_8 n7_8_8 1k
Rz7_7_8 n7_7_8 n7_7_9 1k
Rg7_7_8 n7_7_8 0 50k
Rx7_7_9 n7_7_9 n8_7_9 1k
Ry7_7_9 n7_7_9 n7_8_9 1k
Rz7_7_9 n7_7_9 n7_7_10 1k
Rg7_7_9 n7_7_9 0 50k
Rx7_7_10 n7_7_10 n8_7_10 1k
Ry7_7_10 n7_7_10 n7_8_10 1k
Rg7_7_10 n7_7_10 0 50k
Rx7_8_0 n7_8_0 n8_8_0 1k
Ry7_8_0 n7_8_0 n7_9_0 1k
Rz7_8_0 n7_8_0 n7_8_1 1k
Rg7_8_0 n7_8_0 0 50k
Rx7_8_1 n7_8_1 n8_8_1 1k
Ry7_8_1 n7_8_1 n7_9_1 1k
Rz7_8_1 n7_8_1 n7_8_2 1k
Rg7_8_1 n7_8_1 0 50k
Rx7_8_2 n7_8_2 n8_8_2 1k
Ry7_8_2 n7_8_2 n7_9_2 1k
Rz7_8_2 n7_8_2 n7_8_3 1k
Rg7_8_2 n7_8_2 0 50k
Rx7_8_3 n7_8_3 n8_8_3 1k
Ry7_8_3 n7_8_3 n7_9_3 1k
Rz7_8_3 n7_8_3 n7_8_4 1k
Rg7_8_3 n7_8_3 0 50k
Rx7_8_4 n7_8_4 n8_8_4 1k
Ry7_8_4 n7_8_4 n7_9_4 1k
Rz7_8_4 n7_8_4 n7_8_5 1k
Rg7_8_4 n7_8_4 0 50k
Rx7_8_5 n7_8_5 n8_8_5 1k
Ry7_8_5 n7_8_5 n7_9_5 1k
Rz7_8_5 n7_8_5 n7_8_6 1k
Rg7_8_5 n7_8_5 0 50k
Rx7_8_6 n7_8_6 n8_8_6 1k
Ry7_8_6 n7_8_6 n7_9_6 1k
Rz7_8_6 n7_8_6 n7_8_7 1k
Rg7_8_6 n7_8_6 0 50k
Rx7_8_7 n7_8_7 n8_8_7 1k
Ry7_8_7 n7_8_7 n7_9_7 1k
Rz7_8_7 n7_8_7 n7_8_8 1k
Rg7_8_7 n7_8_7 0 50k
Rx7_8_8 n7_8_8 n8_8_8 1k
Ry7_8_8 n7_8_8 n7_9_8 1k
Rz7_8_8 n7_8_8 n7_8_9 1k
Rg7_8_8 n7_8_8 0 50k
Rx7_8_9 n7_8_9 n8_8_9 1k
Ry7_8_9 n7_8_9 n7_9_9 1k
Rz7_8_9 n7_8_9 n7_8_10 1k
Rg7_8_9 n7_8_9 0 50k
Rx7_8_10 n7_8_10 n8_8_10 1k
Ry7_8_10 n7_8_10 n7_9_10 1k
Rg7_8_10 n7_8_10 0 50k
Rx7_9_0 n7_9_0 n8_9_0 1k
Ry7_9_0 n7_9_0 n7_10_0 1k
Rz7_9_0 n7_9_0 n7_9_1 1k
Rg7_9_0 n7_9_0 0 50k
Rx7_9_1 n7_9_1 n8_9_1 1k
Ry7_9_1 n7_9_1 n7_10_1 1k
Rz7_9_1 n7_9_1 n7_9_2 1k
Rg7_9_1 n7_9_1 0 50k
Rx7_9_2 n7_9_2 n8_9_2 1k
Ry7_9_2 n7_9_2 n7_10_2 1k
Rz7_9_2 n7_9_2 n7_9_3 1k
Rg7_9_2 n7_9_2 0 50k
Rx7_9_3 n7_9_3 n8_9_3 1k
Ry7_9_3 n7_9_3 n7_10_3 1k
Rz7_9_3 n7_9_3 n7_9_4 1k
Rg7_9_3 n7_9_3 0 50k
Rx7_9_4 n7_9_4 n8_9_4 1k
Ry7_9_4 n7_9_4 n7_10_4 1k
Rz7_9_4 n7_9_4 n7_9_5 1k
Rg7_9_4 n7_9_4 0 50k
Rx7_9_5 n7_9_5 n8_9_5 1k
Ry7_9_5 n7_9_5 n7_10_5 1k
Rz7_9_5 n7_9_5 n7_9_6 1k
Rg7_9_5 n7_9_5 0 50k
Rx7_9_6 n7_9_6 n8_9_6 1k
Ry7_9_6 n7_9_6 n7_10_6 1k
Rz7_9_6 n7_9_6 n7_9_7 1k
Rg7_9_6 n7_9_6 0 50k
Rx7_9_7 n7_9_7 n8_9_7 1k
Ry7_9_7 n7_9_7 n7_10_7 1k
Rz7_9_7 n7_9_7 n7_9_8 1k
Rg7_9_7 n7_9_7 0 50k
Rx7_9_8 n7_9_8 n8_9_8 1k
Ry7_9_8 n7_9_8 n7_10_8 1k
Rz7_9_8 n7_9_8 n7_9_9 1k
Rg7_9_8 n7_9_8 0 50k
Rx7_9_9 n7_9_9 n8_9_9 1k
Ry7_9_9 n7_9_9 n7_10_9 1k
Rz7_9_9 n7_9_9 n7_9_10 1k
Rg7_9_9 n7_9_9 0 50k
Rx7_9_10 n7_9_10 n8_9_10 1k
Ry7_9_10 n7_9_10 n7_10_10 1k
Rg7_9_10 n7_9_10 0 50k
Rx7_10_0 n7_10_0 n8_10_0 1k
Rz7_10_0 n7_10_0 n7_10_1 1k
Rg7_10_0 n7_10_0 0 50k
Rx7_10_1 n7_10_1 n8_10_1 1k
Rz7_10_1 n7_10_1 n7_10_2 1k
Rg7_10_1 n7_10_1 0 50k
Rx7_10_2 n7_10_2 n8_10_2 1k
Rz7_10_2 n7_10_2 n7_10_3 1k
Rg7_10_2 n7_10_2 0 50k
Rx7_10_3 n7_10_3 n8_10_3 1k
Rz7_10_3 n7_10_3 n7_10_4 1k
Rg7_10_3 n7_10_3 0 50k
Rx7_10_4 n7_10_4 n8_10_4 1k
Rz7_10_4 n7_10_4 n7_10_5 1k
Rg7_10_4 n7_10_4 0 50k
Rx7_10_5 n7_10_5 n8_10_5 1k
Rz7_10_5 n7_10_5 n7_10_6 1k
Rg7_10_5 n7_10_5 0 50k
Rx7_10_6 n7_10_6 n8_10_6 1k
Rz7_10_6 n7_10_6 n7_10_7 1k
Rg7_10_6 n7_10_6 0 50k
Rx7_10_7 n7_10_7 n8_10_7 1k
Rz7_10_7 n7_10_7 n7_10_8 1k
Rg7_10_7 n7_10_7 0 50k
Rx7_10_8 n7_10_8 n8_10_8 1k
Rz7_10_8 n7_10_8 n7_10_9 1k
Rg7_10_8 n7_10_8 0 50k
Rx7_10_9 n7_10_9 n8_10_9 1k
Rz7_10_9 n7_10_9 n7_10_10 1k
Rg7_10_9 n7_10_9 0 50k
Rx7_10_10 n7_10_10 n8_10_10 1k
Rg7_10_10 n7_10_10 0 50k
Rx8_0_0 n8_0_0 n9_0_0 1k
Ry8_0_0 n8_0_0 n8_1_0 1k
Rz8_0_0 n8_0_0 n8_0_1 1k
Rg8_0_0 n8_0_0 0 50k
Rx8_0_1 n8_0_1 n9_0_1 1k
Ry8_0_1 n8_0_1 n8_1_1 1k
Rz8_0_1 n8_0_1 n8_0_2 1k
Rg8_0_1 n8_0_1 0 50k
Rx8_0_2 n8_0_2 n9_0_2 1k
Ry8_0_2 n8_0_2 n8_1_2 1k
Rz8_0_2 n8_0_2 n8_0_3 1k
Rg8_0_2 n8_0_2 0 50k
Rx8_0_3 n8_0_3 n9_0_3 1k
Ry8_0_3 n8_0_3 n8_1_3 1k
Rz8_0_3 n8_0_3 n8_0_4 1k
Rg8_0_3 n8_0_3 0 50k
Rx8_0_4 n8_0_4 n9_0_4 1k
Ry8_0_4 n8_0_4 n8_1_4 1k
Rz8_0_4 n8_0_4 n8_0_5 1k
Rg8_0_4 n8_0_4 0 50k
Rx8_0_5 n8_0_5 n9_0_5 1k
Ry8_0_5 n8_0_5 n8_1_5 1k
Rz8_0_5 n8_0_5 n8_0_6 1k
Rg8_0_5 n8_0_5 0 50k
Rx8_0_6 n8_0_6 n9_0_6 1k
Ry8_0_6 n8_0_6 n8_1_6 1k
Rz8_0_6 n8_0_6 n8_0_7 1k
Rg8_0_6 n8_0_6 0 50k
Rx8_0_7 n8_0_7 n9_0_7 1k
Ry8_0_7 n8_0_7 n8_1_7 1k
Rz8_0_7 n8_0_7 n8_0_8 1k
Rg8_0_7 n8_0_7 0 50k
Rx8_0_8 n8_0_8 n9_0_8 1k
Ry8_0_8 n8_0_8 n8_1_8 1k
Rz8_0_8 n8_0_8 n8_0_9 1k
Rg8_0_8 n8_0_8 0 50k
Rx8_0_9 n8_0_9 n9_0_9 1k
Ry8_0_9 n8_0_9 n8_1_9 1k
Rz8_0_9 n8_0_9 n8_0_10 1k
Rg8_0_9 n8_0_9 0 50k
Rx8_0_10 n8_0_10 n9_0_10 1k
Ry8_0_10 n8_0_10 n8_1_10 1k
Rg8_0_10 n8_0_10 0 50k
Rx8_1_0 n8_1_0 n9_1_0 1k
Ry8_1_0 n8_1_0 n8_2_0 1k
Rz8_1_0 n8_1_0 n8_1_1 1k
Rg8_1_0 n8_1_0 0 50k
Rx8_1_1 n8_1_1 n9_1_1 1k
Ry8_1_1 n8_1_1 n8_2_1 1k
Rz8_1_1 n8_1_1 n8_1_2 1k
Rg8_1_1 n8_1_1 0 50k
Rx8_1_2 n8_1_2 n9_1_2 1k
Ry8_1_2 n8_1_2 n8_2_2 1k
Rz8_1_2 n8_1_2 n8_1_3 1k
Rg8_1_2 n8_1_2 0 50k
Rx8_1_3 n8_1_3 n9_1_3 1k
Ry8_1_3 n8_1_3 n8_2_3 1k
Rz8_1_3 n8_1_3 n8_1_4 1k
Rg8_1_3 n8_1_3 0 50k
Rx8_1_4 n8_1_4 n9_1_4 1k
Ry8_1_4 n8_1_4 n8_2_4 1k
Rz8_1_4 n8_1_4 n8_1_5 1k
Rg8_1_4 n8_1_4 0 50k
Rx8_1_5 n8_1_5 n9_1_5 1k
Ry8_1_5 n8_1_5 n8_2_5 1k
Rz8_1_5 n8_1_5 n8_1_6 1k
Rg8_1_5 n8_1_5 0 50k
Rx8_1_6 n8_1_6 n9_1_6 1k
Ry8_1_6 n8_1_6 n8_2_6 1k
Rz8_1_6 n8_1_6 n8_1_7 1k
Rg8_1_6 n8_1_6 0 50k
Rx8_1_7 n8_1_7 n9_1_7 1k
Ry8_1_7 n8_1_7 n8_2_7 1k
Rz8_1_7 n8_1_7 n8_1_8 1k
Rg8_1_7 n8_1_7 0 50k
Rx8_1_8 n8_1_8 n9_1_8 1k
Ry8_1_8 n8_1_8 n8_2_8 1k
Rz8_1_8 n8_1_8 n8_1_9 1k
Rg8_1_8 n8_1_8 0 50k
Rx8_1_9 n8_1_9 n9_1_9 1k
Ry8_1_9 n8_1_9 n8_2_9 1k
Rz8_1_9 n8_1_9 n8_1_10 1k
Rg8_1_9 n8_1_9 0 50k
Rx8_1_10 n8_1_10 n9_1_10 1k
Ry8_1_10 n8_1_10 n8_2_10 1k
Rg8_1_10 n8_1_10 0 50k
Rx8_2_0 n8_2_0 n9_2_0 1k
Ry8_2_0 n8_2_0 n8_3_0 1k
Rz8_2_0 n8_2_0 n8_2_1 1k
Rg8_2_0 n8_2_0 0 50k
Rx8_2_1 n8_2_1 n9_2_1 1k
Ry8_2_1 n8_2_1 n8_3_1 1k
Rz8_2_1 n8_2_1 n8_2_2 1k
Rg8_2_1 n8_2_1 0 50k
Rx8_2_2 n8_2_2 n9_2_2 1k
Ry8_2_2 n8_2_2 n8_3_2 1k
Rz8_2_2 n8_2_2 n8_2_3 1k
Rg8_2_2 n8_2_2 0 50k
Rx8_2_3 n8_2_3 n9_2_3 1k
Ry8_2_3 n8_2_3 n8_3_3 1k
Rz8_2_3 n8_2_3 n8_2_4 1k
Rg8_2_3 n8_2_3 0 50k
Rx8_2_4 n8_2_4 n9_2_4 1k
Ry8_2_4 n8_2_4 n8_3_4 1k
Rz8_2_4 n8_2_4 n8_2_5 1k
Rg8_2_4 n8_2_4 0 50k
Rx8_2_5 n8_2_5 n9_2_5 1k
Ry8_2_5 n8_2_5 n8_3_5 1k
Rz8_2_5 n8_2_5 n8_2_6 1k
Rg8_2_5 n8_2_5 0 50k
Rx8_2_6 n8_2_6 n9_2_6 1k
Ry8_2_6 n8_2_6 n8_3_6 1k
Rz8_2_6 n8_2_6 n8_2_7 1k
Rg8_2_6 n8_2_6 0 50k
Rx8_2_7 n8_2_7 n9_2_7 1k
Ry8_2_7 n8_2_7 n8_3_7 1k
Rz8_2_7 n8_2_7 n8_2_8 1k
Rg8_2_7 n8_2_7 0 50k
Rx8_2_8 n8_2_8 n9_2_8 1k
Ry8_2_8 n8_2_8 n8_3_8 1k
Rz8_2_8 n8_2_8 n8_2_9 1k
Rg8_2_8 n8_2_8 0 50k
Rx8_2_9 n8_2_9 n9_2_9 1k
Ry8_2_9 n8_2_9 n8_3_9 1k
Rz8_2_9 n8_2_9 n8_2_10 1k
Rg8_2_9 n8_2_9 0 50k
Rx8_2_10 n8_2_10 n9_2_10 1k
Ry8_2_10 n8_2_10 n8_3_10 1k
Rg8_2_10 n8_2_10 0 50k
Rx8_3_0 n8_3_0 n9_3_0 1k
Ry8_3_0 n8_3_0 n8_4_0 1k
Rz8_3_0 n8_3_0 n8_3_1 1k
Rg8_3_0 n8_3_0 0 50k
Rx8_3_1 n8_3_1 n9_3_1 1k
Ry8_3_1 n8_3_1 n8_4_1 1k
Rz8_3_1 n8_3_1 n8_3_2 1k
Rg8_3_1 n8_3_1 0 50k
Rx8_3_2 n8_3_2 n9_3_2 1k
Ry8_3_2 n8_3_2 n8_4_2 1k
Rz8_3_2 n8_3_2 n8_3_3 1k
Rg8_3_2 n8_3_2 0 50k
Rx8_3_3 n8_3_3 n9_3_3 1k
Ry8_3_3 n8_3_3 n8_4_3 1k
Rz8_3_3 n8_3_3 n8_3_4 1k
Rg8_3_3 n8_3_3 0 50k
Rx8_3_4 n8_3_4 n9_3_4 1k
Ry8_3_4 n8_3_4 n8_4_4 1k
Rz8_3_4 n8_3_4 n8_3_5 1k
Rg8_3_4 n8_3_4 0 50k
Rx8_3_5 n8_3_5 n9_3_5 1k
Ry8_3_5 n8_3_5 n8_4_5 1k
Rz8_3_5 n8_3_5 n8_3_6 1k
Rg8_3_5 n8_3_5 0 50k
Rx8_3_6 n8_3_6 n9_3_6 1k
Ry8_3_6 n8_3_6 n8_4_6 1k
Rz8_3_6 n8_3_6 n8_3_7 1k
Rg8_3_6 n8_3_6 0 50k
Rx8_3_7 n8_3_7 n9_3_7 1k
Ry8_3_7 n8_3_7 n8_4_7 1k
Rz8_3_7 n8_3_7 n8_3_8 1k
Rg8_3_7 n8_3_7 0 50k
Rx8_3_8 n8_3_8 n9_3_8 1k
Ry8_3_8 n8_3_8 n8_4_8 1k
Rz8_3_8 n8_3_8 n8_3_9 1k
Rg8_3_8 n8_3_8 0 50k
Rx8_3_9 n8_3_9 n9_3_9 1k
Ry8_3_9 n8_3_9 n8_4_9 1k
Rz8_3_9 n8_3_9 n8_3_10 1k
Rg8_3_9 n8_3_9 0 50k
Rx8_3_10 n8_3_10 n9_3_10 1k
Ry8_3_10 n8_3_10 n8_4_10 1k
Rg8_3_10 n8_3_10 0 50k
Rx8_4_0 n8_4_0 n9_4_0 1k
Ry8_4_0 n8_4_0 n8_5_0 1k
Rz8_4_0 n8_4_0 n8_4_1 1k
Rg8_4_0 n8_4_0 0 50k
Rx8_4_1 n8_4_1 n9_4_1 1k
Ry8_4_1 n8_4_1 n8_5_1 1k
Rz8_4_1 n8_4_1 n8_4_2 1k
Rg8_4_1 n8_4_1 0 50k
Rx8_4_2 n8_4_2 n9_4_2 1k
Ry8_4_2 n8_4_2 n8_5_2 1k
Rz8_4_2 n8_4_2 n8_4_3 1k
Rg8_4_2 n8_4_2 0 50k
Rx8_4_3 n8_4_3 n9_4_3 1k
Ry8_4_3 n8_4_3 n8_5_3 1k
Rz8_4_3 n8_4_3 n8_4_4 1k
Rg8_4_3 n8_4_3 0 50k
Rx8_4_4 n8_4_4 n9_4_4 1k
Ry8_4_4 n8_4_4 n8_5_4 1k
Rz8_4_4 n8_4_4 n8_4_5 1k
Rg8_4_4 n8_4_4 0 50k
Rx8_4_5 n8_4_5 n9_4_5 1k
Ry8_4_5 n8_4_5 n8_5_5 1k
Rz8_4_5 n8_4_5 n8_4_6 1k
Rg8_4_5 n8_4_5 0 50k
Rx8_4_6 n8_4_6 n9_4_6 1k
Ry8_4_6 n8_4_6 n8_5_6 1k
Rz8_4_6 n8_4_6 n8_4_7 1k
Rg8_4_6 n8_4_6 0 50k
Rx8_4_7 n8_4_7 n9_4_7 1k
Ry8_4_7 n8_4_7 n8_5_7 1k
Rz8_4_7 n8_4_7 n8_4_8 1k
Rg8_4_7 n8_4_7 0 50k
Rx8_4_8 n8_4_8 n9_4_8 1k
Ry8_4_8 n8_4_8 n8_5_8 1k
Rz8_4_8 n8_4_8 n8_4_9 1k
Rg8_4_8 n8_4_8 0 50k
Rx8_4_9 n8_4_9 n9_4_9 1k
Ry8_4_9 n8_4_9 n8_5_9 1k
Rz8_4_9 n8_4_9 n8_4_10 1k
Rg8_4_9 n8_4_9 0 50k
Rx8_4_10 n8_4_10 n9_4_10 1k
Ry8_4_10 n8_4_10 n8_5_10 1k
Rg8_4_10 n8_4_10 0 50k
Rx8_5_0 n8_5_0 n9_5_0 1k
Ry8_5_0 n8_5_0 n8_6_0 1k
Rz8_5_0 n8_5_0 n8_5_1 1k
Rg8_5_0 n8_5_0 0 50k
Rx8_5_1 n8_5_1 n9_5_1 1k
Ry8_5_1 n8_5_1 n8_6_1 1k
Rz8_5_1 n8_5_1 n8_5_2 1k
Rg8_5_1 n8_5_1 0 50k
Rx8_5_2 n8_5_2 n9_5_2 1k
Ry8_5_2 n8_5_2 n8_6_2 1k
Rz8_5_2 n8_5_2 n8_5_3 1k
Rg8_5_2 n8_5_2 0 50k
Rx8_5_3 n8_5_3 n9_5_3 1k
Ry8_5_3 n8_5_3 n8_6_3 1k
Rz8_5_3 n8_5_3 n8_5_4 1k
Rg8_5_3 n8_5_3 0 50k
Rx8_5_4 n8_5_4 n9_5_4 1k
Ry8_5_4 n8_5_4 n8_6_4 1k
Rz8_5_4 n8_5_4 n8_5_5 1k
Rg8_5_4 n8_5_4 0 50k
Rx8_5_5 n8_5_5 n9_5_5 1k
Ry8_5_5 n8_5_5 n8_6_5 1k
Rz8_5_5 n8_5_5 n8_5_6 1k
Rg8_5_5 n8_5_5 0 50k
Rx8_5_6 n8_5_6 n9_5_6 1k
Ry8_5_6 n8_5_6 n8_6_6 1k
Rz8_5_6 n8_5_6 n8_5_7 1k
Rg8_5_6 n8_5_6 0 50k
Rx8_5_7 n8_5_7 n9_5_7 1k
Ry8_5_7 n8_5_7 n8_6_7 1k
Rz8_5_7 n8_5_7 n8_5_8 1k
Rg8_5_7 n8_5_7 0 50k
Rx8_5_8 n8_5_8 n9_5_8 1k
Ry8_5_8 n8_5_8 n8_6_8 1k
Rz8_5_8 n8_5_8 n8_5_9 1k
Rg8_5_8 n8_5_8 0 50k
Rx8_5_9 n8_5_9 n9_5_9 1k
Ry8_5_9 n8_5_9 n8_6_9 1k
Rz8_5_9 n8_5_9 n8_5_10 1k
Rg8_5_9 n8_5_9 0 50k
Rx8_5_10 n8_5_10 n9_5_10 1k
Ry8_5_10 n8_5_10 n8_6_10 1k
Rg8_5_10 n8_5_10 0 50k
Rx8_6_0 n8_6_0 n9_6_0 1k
Ry8_6_0 n8_6_0 n8_7_0 1k
Rz8_6_0 n8_6_0 n8_6_1 1k
Rg8_6_0 n8_6_0 0 50k
Rx8_6_1 n8_6_1 n9_6_1 1k
Ry8_6_1 n8_6_1 n8_7_1 1k
Rz8_6_1 n8_6_1 n8_6_2 1k
Rg8_6_1 n8_6_1 0 50k
Rx8_6_2 n8_6_2 n9_6_2 1k
Ry8_6_2 n8_6_2 n8_7_2 1k
Rz8_6_2 n8_6_2 n8_6_3 1k
Rg8_6_2 n8_6_2 0 50k
Rx8_6_3 n8_6_3 n9_6_3 1k
Ry8_6_3 n8_6_3 n8_7_3 1k
Rz8_6_3 n8_6_3 n8_6_4 1k
Rg8_6_3 n8_6_3 0 50k
Rx8_6_4 n8_6_4 n9_6_4 1k
Ry8_6_4 n8_6_4 n8_7_4 1k
Rz8_6_4 n8_6_4 n8_6_5 1k
Rg8_6_4 n8_6_4 0 50k
Rx8_6_5 n8_6_5 n9_6_5 1k
Ry8_6_5 n8_6_5 n8_7_5 1k
Rz8_6_5 n8_6_5 n8_6_6 1k
Rg8_6_5 n8_6_5 0 50k
Rx8_6_6 n8_6_6 n9_6_6 1k
Ry8_6_6 n8_6_6 n8_7_6 1k
Rz8_6_6 n8_6_6 n8_6_7 1k
Rg8_6_6 n8_6_6 0 50k
Rx8_6_7 n8_6_7 n9_6_7 1k
Ry8_6_7 n8_6_7 n8_7_7 1k
Rz8_6_7 n8_6_7 n8_6_8 1k
Rg8_6_7 n8_6_7 0 50k
Rx8_6_8 n8_6_8 n9_6_8 1k
Ry8_6_8 n8_6_8 n8_7_8 1k
Rz8_6_8 n8_6_8 n8_6_9 1k
Rg8_6_8 n8_6_8 0 50k
Rx8_6_9 n8_6_9 n9_6_9 1k
Ry8_6_9 n8_6_9 n8_7_9 1k
Rz8_6_9 n8_6_9 n8_6_10 1k
Rg8_6_9 n8_6_9 0 50k
Rx8_6_10 n8_6_10 n9_6_10 1k
Ry8_6_10 n8_6_10 n8_7_10 1k
Rg8_6_10 n8_6_10 0 50k
Rx8_7_0 n8_7_0 n9_7_0 1k
Ry8_7_0 n8_7_0 n8_8_0 1k
Rz8_7_0 n8_7_0 n8_7_1 1k
Rg8_7_0 n8_7_0 0 50k
Rx8_7_1 n8_7_1 n9_7_1 1k
Ry8_7_1 n8_7_1 n8_8_1 1k
Rz8_7_1 n8_7_1 n8_7_2 1k
Rg8_7_1 n8_7_1 0 50k
Rx8_7_2 n8_7_2 n9_7_2 1k
Ry8_7_2 n8_7_2 n8_8_2 1k
Rz8_7_2 n8_7_2 n8_7_3 1k
Rg8_7_2 n8_7_2 0 50k
Rx8_7_3 n8_7_3 n9_7_3 1k
Ry8_7_3 n8_7_3 n8_8_3 1k
Rz8_7_3 n8_7_3 n8_7_4 1k
Rg8_7_3 n8_7_3 0 50k
Rx8_7_4 n8_7_4 n9_7_4 1k
Ry8_7_4 n8_7_4 n8_8_4 1k
Rz8_7_4 n8_7_4 n8_7_5 1k
Rg8_7_4 n8_7_4 0 50k
Rx8_7_5 n8_7_5 n9_7_5 1k
Ry8_7_5 n8_7_5 n8_8_5 1k
Rz8_7_5 n8_7_5 n8_7_6 1k
Rg8_7_5 n8_7_5 0 50k
Rx8_7_6 n8_7_6 n9_7_6 1k
Ry8_7_6 n8_7_6 n8_8_6 1k
Rz8_7_6 n8_7_6 n8_7_7 1k
Rg8_7_6 n8_7_6 0 50k
Rx8_7_7 n8_7_7 n9_7_7 1k
Ry8_7_7 n8_7_7 n8_8_7 1k
Rz8_7_7 n8_7_7 n8_7_8 1k
Rg8_7_7 n8_7_7 0 50k
Rx8_7_8 n8_7_8 n9_7_8 1k
Ry8_7_8 n8_7_8 n8_8_8 1k
Rz8_7_8 n8_7_8 n8_7_9 1k
Rg8_7_8 n8_7_8 0 50k
Rx8_7_9 n8_7_9 n9_7_9 1k
Ry8_7_9 n8_7_9 n8_8_9 1k
Rz8_7_9 n8_7_9 n8_7_10 1k
Rg8_7_9 n8_7_9 0 50k
Rx8_7_10 n8_7_10 n9_7_10 1k
Ry8_7_10 n8_7_10 n8_8_10 1k
Rg8_7_10 n8_7_10 0 50k
Rx8_8_0 n8_8_0 n9_8_0 1k
Ry8_8_0 n8_8_0 n8_9_0 1k
Rz8_8_0 n8_8_0 n8_8_1 1k
Rg8_8_0 n8_8_0 0 50k
Rx8_8_1 n8_8_1 n9_8_1 1k
Ry8_8_1 n8_8_1 n8_9_1 1k
Rz8_8_1 n8_8_1 n8_8_2 1k
Rg8_8_1 n8_8_1 0 50k
Rx8_8_2 n8_8_2 n9_8_2 1k
Ry8_8_2 n8_8_2 n8_9_2 1k
Rz8_8_2 n8_8_2 n8_8_3 1k
Rg8_8_2 n8_8_2 0 50k
Rx8_8_3 n8_8_3 n9_8_3 1k
Ry8_8_3 n8_8_3 n8_9_3 1k
Rz8_8_3 n8_8_3 n8_8_4 1k
Rg8_8_3 n8_8_3 0 50k
Rx8_8_4 n8_8_4 n9_8_4 1k
Ry8_8_4 n8_8_4 n8_9_4 1k
Rz8_8_4 n8_8_4 n8_8_5 1k
Rg8_8_4 n8_8_4 0 50k
Rx8_8_5 n8_8_5 n9_8_5 1k
Ry8_8_5 n8_8_5 n8_9_5 1k
Rz8_8_5 n8_8_5 n8_8_6 1k
Rg8_8_5 n8_8_5 0 50k
Rx8_8_6 n8_8_6 n9_8_6 1k
Ry8_8_6 n8_8_6 n8_9_6 1k
Rz8_8_6 n8_8_6 n8_8_7 1k
Rg8_8_6 n8_8_6 0 50k
Rx8_8_7 n8_8_7 n9_8_7 1k
Ry8_8_7 n8_8_7 n8_9_7 1k
Rz8_8_7 n8_8_7 n8_8_8 1k
Rg8_8_7 n8_8_7 0 50k
Rx8_8_8 n8_8_8 n9_8_8 1k
Ry8_8_8 n8_8_8 n8_9_8 1k
Rz8_8_8 n8_8_8 n8_8_9 1k
Rg8_8_8 n8_8_8 0 50k
Rx8_8_9 n8_8_9 n9_8_9 1k
Ry8_8_9 n8_8_9 n8_9_9 1k
Rz8_8_9 n8_8_9 n8_8_10 1k
Rg8_8_9 n8_8_9 0 50k
Rx8_8_10 n8_8_10 n9_8_10 1k
Ry8_8_10 n8_8_10 n8_9_10 1k
Rg8_8_10 n8_8_10 0 50k
Rx8_9_0 n8_9_0 n9_9_0 1k
Ry8_9_0 n8_9_0 n8_10_0 1k
Rz8_9_0 n8_9_0 n8_9_1 1k
Rg8_9_0 n8_9_0 0 50k
Rx8_9_1 n8_9_1 n9_9_1 1k
Ry8_9_1 n8_9_1 n8_10_1 1k
Rz8_9_1 n8_9_1 n8_9_2 1k
Rg8_9_1 n8_9_1 0 50k
Rx8_9_2 n8_9_2 n9_9_2 1k
Ry8_9_2 n8_9_2 n8_10_2 1k
Rz8_9_2 n8_9_2 n8_9_3 1k
Rg8_9_2 n8_9_2 0 50k
Rx8_9_3 n8_9_3 n9_9_3 1k
Ry8_9_3 n8_9_3 n8_10_3 1k
Rz8_9_3 n8_9_3 n8_9_4 1k
Rg8_9_3 n8_9_3 0 50k
Rx8_9_4 n8_9_4 n9_9_4 1k
Ry8_9_4 n8_9_4 n8_10_4 1k
Rz8_9_4 n8_9_4 n8_9_5 1k
Rg8_9_4 n8_9_4 0 50k
Rx8_9_5 n8_9_5 n9_9_5 1k
Ry8_9_5 n8_9_5 n8_10_5 1k
Rz8_9_5 n8_9_5 n8_9_6 1k
Rg8_9_5 n8_9_5 0 50k
Rx8_9_6 n8_9_6 n9_9_6 1k
Ry8_9_6 n8_9_6 n8_10_6 1k
Rz8_9_6 n8_9_6 n8_9_7 1k
Rg8_9_6 n8_9_6 0 50k
Rx8_9_7 n8_9_7 n9_9_7 1k
Ry8_9_7 n8_9_7 n8_10_7 1k
Rz8_9_7 n8_9_7 n8_9_8 1k
Rg8_9_7 n8_9_7 0 50k
Rx8_9_8 n8_9_8 n9_9_8 1k
Ry8_9_8 n8_9_8 n8_10_8 1k
Rz8_9_8 n8_9_8 n8_9_9 1k
Rg8_9_8 n8_9_8 0 50k
Rx8_9_9 n8_9_9 n9_9_9 1k
Ry8_9_9 n8_9_9 n8_10_9 1k
Rz8_9_9 n8_9_9 n8_9_10 1k
Rg8_9_9 n8_9_9 0 50k
Rx8_9_10 n8_9_10 n9_9_10 1k
Ry8_9_10 n8_9_10 n8_10_10 1k
Rg8_9_10 n8_9_10 0 50k
Rx8_10_0 n8_10_0 n9_10_0 1k
Rz8_10_0 n8_10_0 n8_10_1 1k
Rg8_10_0 n8_10_0 0 50k
Rx8_10_1 n8_10_1 n9_10_1 1k
Rz8_10_1 n8_10_1 n8_10_2 1k
Rg8_10_1 n8_10_1 0 50k
Rx8_10_2 n8_10_2 n9_10_2 1k
Rz8_10_2 n8_10_2 n8_10_3 1k
Rg8_10_2 n8_10_2 0 50k
Rx8_10_3 n8_10_3 n9_10_3 1k
Rz8_10_3 n8_10_3 n8_10_4 1k
Rg8_10_3 n8_10_3 0 50k
Rx8_10_4 n8_10_4 n9_10_4 1k
Rz8_10_4 n8_10_4 n8_10_5 1k
Rg8_10_4 n8_10_4 0 50k
Rx8_10_5 n8_10_5 n9_10_5 1k
Rz8_10_5 n8_10_5 n8_10_6 1k
Rg8_10_5 n8_10_5 0 50k
Rx8_10_6 n8_10_6 n9_10_6 1k
Rz8_10_6 n8_10_6 n8_10_7 1k
Rg8_10_6 n8_10_6 0 50k
Rx8_10_7 n8_10_7 n9_10_7 1k
Rz8_10_7 n8_10_7 n8_10_8 1k
Rg8_10_7 n8_10_7 0 50k
Rx8_10_8 n8_10_8 n9_10_8 1k
Rz8_10_8 n8_10_8 n8_10_9 1k
Rg8_10_8 n8_10_8 0 50k
Rx8_10_9 n8_10_9 n9_10_9 1k
Rz8_10_9 n8_10_9 n8_10_10 1k
Rg8_10_9 n8_10_9 0 50k
Rx8_10_10 n8_10_10 n9_10_10 1k
Rg8_10_10 n8_10_10 0 50k
Rx9_0_0 n9_0_0 n10_0_0 1k
Ry9_0_0 n9_0_0 n9_1_0 1k
Rz9_0_0 n9_0_0 n9_0_1 1k
Rg9_0_0 n9_0_0 0 50k
Rx9_0_1 n9_0_1 n10_0_1 1k
Ry9_0_1 n9_0_1 n9_1_1 1k
Rz9_0_1 n9_0_1 n9_0_2 1k
Rg9_0_1 n9_0_1 0 50k
Rx9_0_2 n9_0_2 n10_0_2 1k
Ry9_0_2 n9_0_2 n9_1_2 1k
Rz9_0_2 n9_0_2 n9_0_3 1k
Rg9_0_2 n9_0_2 0 50k
Rx9_0_3 n9_0_3 n10_0_3 1k
Ry9_0_3 n9_0_3 n9_1_3 1k
Rz9_0_3 n9_0_3 n9_0_4 1k
Rg9_0_3 n9_0_3 0 50k
Rx9_0_4 n9_0_4 n10_0_4 1k
Ry9_0_4 n9_0_4 n9_1_4 1k
Rz9_0_4 n9_0_4 n9_0_5 1k
Rg9_0_4 n9_0_4 0 50k
Rx9_0_5 n9_0_5 n10_0_5 1k
Ry9_0_5 n9_0_5 n9_1_5 1k
Rz9_0_5 n9_0_5 n9_0_6 1k
Rg9_0_5 n9_0_5 0 50k
Rx9_0_6 n9_0_6 n10_0_6 1k
Ry9_0_6 n9_0_6 n9_1_6 1k
Rz9_0_6 n9_0_6 n9_0_7 1k
Rg9_0_6 n9_0_6 0 50k
Rx9_0_7 n9_0_7 n10_0_7 1k
Ry9_0_7 n9_0_7 n9_1_7 1k
Rz9_0_7 n9_0_7 n9_0_8 1k
Rg9_0_7 n9_0_7 0 50k
Rx9_0_8 n9_0_8 n10_0_8 1k
Ry9_0_8 n9_0_8 n9_1_8 1k
Rz9_0_8 n9_0_8 n9_0_9 1k
Rg9_0_8 n9_0_8 0 50k
Rx9_0_9 n9_0_9 n10_0_9 1k
Ry9_0_9 n9_0_9 n9_1_9 1k
Rz9_0_9 n9_0_9 n9_0_10 1k
Rg9_0_9 n9_0_9 0 50k
Rx9_0_10 n9_0_10 n10_0_10 1k
Ry9_0_10 n9_0_10 n9_1_10 1k
Rg9_0_10 n9_0_10 0 50k
Rx9_1_0 n9_1_0 n10_1_0 1k
Ry9_1_0 n9_1_0 n9_2_0 1k
Rz9_1_0 n9_1_0 n9_1_1 1k
Rg9_1_0 n9_1_0 0 50k
Rx9_1_1 n9_1_1 n10_1_1 1k
Ry9_1_1 n9_1_1 n9_2_1 1k
Rz9_1_1 n9_1_1 n9_1_2 1k
Rg9_1_1 n9_1_1 0 50k
Rx9_1_2 n9_1_2 n10_1_2 1k
Ry9_1_2 n9_1_2 n9_2_2 1k
Rz9_1_2 n9_1_2 n9_1_3 1k
Rg9_1_2 n9_1_2 0 50k
Rx9_1_3 n9_1_3 n10_1_3 1k
Ry9_1_3 n9_1_3 n9_2_3 1k
Rz9_1_3 n9_1_3 n9_1_4 1k
Rg9_1_3 n9_1_3 0 50k
Rx9_1_4 n9_1_4 n10_1_4 1k
Ry9_1_4 n9_1_4 n9_2_4 1k
Rz9_1_4 n9_1_4 n9_1_5 1k
Rg9_1_4 n9_1_4 0 50k
Rx9_1_5 n9_1_5 n10_1_5 1k
Ry9_1_5 n9_1_5 n9_2_5 1k
Rz9_1_5 n9_1_5 n9_1_6 1k
Rg9_1_5 n9_1_5 0 50k
Rx9_1_6 n9_1_6 n10_1_6 1k
Ry9_1_6 n9_1_6 n9_2_6 1k
Rz9_1_6 n9_1_6 n9_1_7 1k
Rg9_1_6 n9_1_6 0 50k
Rx9_1_7 n9_1_7 n10_1_7 1k
Ry9_1_7 n9_1_7 n9_2_7 1k
Rz9_1_7 n9_1_7 n9_1_8 1k
Rg9_1_7 n9_1_7 0 50k
Rx9_1_8 n9_1_8 n10_1_8 1k
Ry9_1_8 n9_1_8 n9_2_8 1k
Rz9_1_8 n9_1_8 n9_1_9 1k
Rg9_1_8 n9_1_8 0 50k
Rx9_1_9 n9_1_9 n10_1_9 1k
Ry9_1_9 n9_1_9 n9_2_9 1k
Rz9_1_9 n9_1_9 n9_1_10 1k
Rg9_1_9 n9_1_9 0 50k
Rx9_1_10 n9_1_10 n10_1_10 1k
Ry9_1_10 n9_1_10 n9_2_10 1k
Rg9_1_10 n9_1_10 0 50k
Rx9_2_0 n9_2_0 n10_2_0 1k
Ry9_2_0 n9_2_0 n9_3_0 1k
Rz9_2_0 n9_2_0 n9_2_1 1k
Rg9_2_0 n9_2_0 0 50k
Rx9_2_1 n9_2_1 n10_2_1 1k
Ry9_2_1 n9_2_1 n9_3_1 1k
Rz9_2_1 n9_2_1 n9_2_2 1k
Rg9_2_1 n9_2_1 0 50k
Rx9_2_2 n9_2_2 n10_2_2 1k
Ry9_2_2 n9_2_2 n9_3_2 1k
Rz9_2_2 n9_2_2 n9_2_3 1k
Rg9_2_2 n9_2_2 0 50k
Rx9_2_3 n9_2_3 n10_2_3 1k
Ry9_2_3 n9_2_3 n9_3_3 1k
Rz9_2_3 n9_2_3 n9_2_4 1k
Rg9_2_3 n9_2_3 0 50k
Rx9_2_4 n9_2_4 n10_2_4 1k
Ry9_2_4 n9_2_4 n9_3_4 1k
Rz9_2_4 n9_2_4 n9_2_5 1k
Rg9_2_4 n9_2_4 0 50k
Rx9_2_5 n9_2_5 n10_2_5 1k
Ry9_2_5 n9_2_5 n9_3_5 1k
Rz9_2_5 n9_2_5 n9_2_6 1k
Rg9_2_5 n9_2_5 0 50k
Rx9_2_6 n9_2_6 n10_2_6 1k
Ry9_2_6 n9_2_6 n9_3_6 1k
Rz9_2_6 n9_2_6 n9_2_7 1k
Rg9_2_6 n9_2_6 0 50k
Rx9_2_7 n9_2_7 n10_2_7 1k
Ry9_2_7 n9_2_7 n9_3_7 1k
Rz9_2_7 n9_2_7 n9_2_8 1k
Rg9_2_7 n9_2_7 0 50k
Rx9_2_8 n9_2_8 n10_2_8 1k
Ry9_2_8 n9_2_8 n9_3_8 1k
Rz9_2_8 n9_2_8 n9_2_9 1k
Rg9_2_8 n9_2_8 0 50k
Rx9_2_9 n9_2_9 n10_2_9 1k
Ry9_2_9 n9_2_9 n9_3_9 1k
Rz9_2_9 n9_2_9 n9_2_10 1k
Rg9_2_9 n9_2_9 0 50k
Rx9_2_10 n9_2_10 n10_2_10 1k
Ry9_2_10 n9_2_10 n9_3_10 1k
Rg9_2_10 n9_2_10 0 50k
Rx9_3_0 n9_3_0 n10_3_0 1k
Ry9_3_0 n9_3_0 n9_4_0 1k
Rz9_3_0 n9_3_0 n9_3_1 1k
Rg9_3_0 n9_3_0 0 50k
Rx9_3_1 n9_3_1 n10_3_1 1k
Ry9_3_1 n9_3_1 n9_4_1 1k
Rz9_3_1 n9_3_1 n9_3_2 1k
Rg9_3_1 n9_3_1 0 50k
Rx9_3_2 n9_3_2 n10_3_2 1k
Ry9_3_2 n9_3_2 n9_4_2 1k
Rz9_3_2 n9_3_2 n9_3_3 1k
Rg9_3_2 n9_3_2 0 50k
Rx9_3_3 n9_3_3 n10_3_3 1k
Ry9_3_3 n9_3_3 n9_4_3 1k
Rz9_3_3 n9_3_3 n9_3_4 1k
Rg9_3_3 n9_3_3 0 50k
Rx9_3_4 n9_3_4 n10_3_4 1k
Ry9_3_4 n9_3_4 n9_4_4 1k
Rz9_3_4 n9_3_4 n9_3_5 1k
Rg9_3_4 n9_3_4 0 50k
Rx9_3_5 n9_3_5 n10_3_5 1k
Ry9_3_5 n9_3_5 n9_4_5 1k
Rz9_3_5 n9_3_5 n9_3_6 1k
Rg9_3_5 n9_3_5 0 50k
Rx9_3_6 n9_3_6 n10_3_6 1k
Ry9_3_6 n9_3_6 n9_4_6 1k
Rz9_3_6 n9_3_6 n9_3_7 1k
Rg9_3_6 n9_3_6 0 50k
Rx9_3_7 n9_3_7 n10_3_7 1k
Ry9_3_7 n9_3_7 n9_4_7 1k
Rz9_3_7 n9_3_7 n9_3_8 1k
Rg9_3_7 n9_3_7 0 50k
Rx9_3_8 n9_3_8 n10_3_8 1k
Ry9_3_8 n9_3_8 n9_4_8 1k
Rz9_3_8 n9_3_8 n9_3_9 1k
Rg9_3_8 n9_3_8 0 50k
Rx9_3_9 n9_3_9 n10_3_9 1k
Ry9_3_9 n9_3_9 n9_4_9 1k
Rz9_3_9 n9_3_9 n9_3_10 1k
Rg9_3_9 n9_3_9 0 50k
Rx9_3_10 n9_3_10 n10_3_10 1k
Ry9_3_10 n9_3_10 n9_4_10 1k
Rg9_3_10 n9_3_10 0 50k
Rx9_4_0 n9_4_0 n10_4_0 1k
Ry9_4_0 n9_4_0 n9_5_0 1k
Rz9_4_0 n9_4_0 n9_4_1 1k
Rg9_4_0 n9_4_0 0 50k
Rx9_4_1 n9_4_1 n10_4_1 1k
Ry9_4_1 n9_4_1 n9_5_1 1k
Rz9_4_1 n9_4_1 n9_4_2 1k
Rg9_4_1 n9_4_1 0 50k
Rx9_4_2 n9_4_2 n10_4_2 1k
Ry9_4_2 n9_4_2 n9_5_2 1k
Rz9_4_2 n9_4_2 n9_4_3 1k
Rg9_4_2 n9_4_2 0 50k
Rx9_4_3 n9_4_3 n10_4_3 1k
Ry9_4_3 n9_4_3 n9_5_3 1k
Rz9_4_3 n9_4_3 n9_4_4 1k
Rg9_4_3 n9_4_3 0 50k
Rx9_4_4 n9_4_4 n10_4_4 1k
Ry9_4_4 n9_4_4 n9_5_4 1k
Rz9_4_4 n9_4_4 n9_4_5 1k
Rg9_4_4 n9_4_4 0 50k
Rx9_4_5 n9_4_5 n10_4_5 1k
Ry9_4_5 n9_4_5 n9_5_5 1k
Rz9_4_5 n9_4_5 n9_4_6 1k
Rg9_4_5 n9_4_5 0 50k
Rx9_4_6 n9_4_6 n10_4_6 1k
Ry9_4_6 n9_4_6 n9_5_6 1k
Rz9_4_6 n9_4_6 n9_4_7 1k
Rg9_4_6 n9_4_6 0 50k
Rx9_4_7 n9_4_7 n10_4_7 1k
Ry9_4_7 n9_4_7 n9_5_7 1k
Rz9_4_7 n9_4_7 n9_4_8 1k
Rg9_4_7 n9_4_7 0 50k
Rx9_4_8 n9_4_8 n10_4_8 1k
Ry9_4_8 n9_4_8 n9_5_8 1k
Rz9_4_8 n9_4_8 n9_4_9 1k
Rg9_4_8 n9_4_8 0 50k
Rx9_4_9 n9_4_9 n10_4_9 1k
Ry9_4_9 n9_4_9 n9_5_9 1k
Rz9_4_9 n9_4_9 n9_4_10 1k
Rg9_4_9 n9_4_9 0 50k
Rx9_4_10 n9_4_10 n10_4_10 1k
Ry9_4_10 n9_4_10 n9_5_10 1k
Rg9_4_10 n9_4_10 0 50k
Rx9_5_0 n9_5_0 n10_5_0 1k
Ry9_5_0 n9_5_0 n9_6_0 1k
Rz9_5_0 n9_5_0 n9_5_1 1k
Rg9_5_0 n9_5_0 0 50k
Rx9_5_1 n9_5_1 n10_5_1 1k
Ry9_5_1 n9_5_1 n9_6_1 1k
Rz9_5_1 n9_5_1 n9_5_2 1k
Rg9_5_1 n9_5_1 0 50k
Rx9_5_2 n9_5_2 n10_5_2 1k
Ry9_5_2 n9_5_2 n9_6_2 1k
Rz9_5_2 n9_5_2 n9_5_3 1k
Rg9_5_2 n9_5_2 0 50k
Rx9_5_3 n9_5_3 n10_5_3 1k
Ry9_5_3 n9_5_3 n9_6_3 1k
Rz9_5_3 n9_5_3 n9_5_4 1k
Rg9_5_3 n9_5_3 0 50k
Rx9_5_4 n9_5_4 n10_5_4 1k
Ry9_5_4 n9_5_4 n9_6_4 1k
Rz9_5_4 n9_5_4 n9_5_5 1k
Rg9_5_4 n9_5_4 0 50k
Rx9_5_5 n9_5_5 n10_5_5 1k
Ry9_5_5 n9_5_5 n9_6_5 1k
Rz9_5_5 n9_5_5 n9_5_6 1k
Rg9_5_5 n9_5_5 0 50k
Rx9_5_6 n9_5_6 n10_5_6 1k
Ry9_5_6 n9_5_6 n9_6_6 1k
Rz9_5_6 n9_5_6 n9_5_7 1k
Rg9_5_6 n9_5_6 0 50k
Rx9_5_7 n9_5_7 n10_5_7 1k
Ry9_5_7 n9_5_7 n9_6_7 1k
Rz9_5_7 n9_5_7 n9_5_8 1k
Rg9_5_7 n9_5_7 0 50k
Rx9_5_8 n9_5_8 n10_5_8 1k
Ry9_5_8 n9_5_8 n9_6_8 1k
Rz9_5_8 n9_5_8 n9_5_9 1k
Rg9_5_8 n9_5_8 0 50k
Rx9_5_9 n9_5_9 n10_5_9 1k
Ry9_5_9 n9_5_9 n9_6_9 1k
Rz9_5_9 n9_5_9 n9_5_10 1k
Rg9_5_9 n9_5_9 0 50k
Rx9_5_10 n9_5_10 n10_5_10 1k
Ry9_5_10 n9_5_10 n9_6_10 1k
Rg9_5_10 n9_5_10 0 50k
Rx9_6_0 n9_6_0 n10_6_0 1k
Ry9_6_0 n9_6_0 n9_7_0 1k
Rz9_6_0 n9_6_0 n9_6_1 1k
Rg9_6_0 n9_6_0 0 50k
Rx9_6_1 n9_6_1 n10_6_1 1k
Ry9_6_1 n9_6_1 n9_7_1 1k
Rz9_6_1 n9_6_1 n9_6_2 1k
Rg9_6_1 n9_6_1 0 50k
Rx9_6_2 n9_6_2 n10_6_2 1k
Ry9_6_2 n9_6_2 n9_7_2 1k
Rz9_6_2 n9_6_2 n9_6_3 1k
Rg9_6_2 n9_6_2 0 50k
Rx9_6_3 n9_6_3 n10_6_3 1k
Ry9_6_3 n9_6_3 n9_7_3 1k
Rz9_6_3 n9_6_3 n9_6_4 1k
Rg9_6_3 n9_6_3 0 50k
Rx9_6_4 n9_6_4 n10_6_4 1k
Ry9_6_4 n9_6_4 n9_7_4 1k
Rz9_6_4 n9_6_4 n9_6_5 1k
Rg9_6_4 n9_6_4 0 50k
Rx9_6_5 n9_6_5 n10_6_5 1k
Ry9_6_5 n9_6_5 n9_7_5 1k
Rz9_6_5 n9_6_5 n9_6_6 1k
Rg9_6_5 n9_6_5 0 50k
Rx9_6_6 n9_6_6 n10_6_6 1k
Ry9_6_6 n9_6_6 n9_7_6 1k
Rz9_6_6 n9_6_6 n9_6_7 1k
Rg9_6_6 n9_6_6 0 50k
Rx9_6_7 n9_6_7 n10_6_7 1k
Ry9_6_7 n9_6_7 n9_7_7 1k
Rz9_6_7 n9_6_7 n9_6_8 1k
Rg9_6_7 n9_6_7 0 50k
Rx9_6_8 n9_6_8 n10_6_8 1k
Ry9_6_8 n9_6_8 n9_7_8 1k
Rz9_6_8 n9_6_8 n9_6_9 1k
Rg9_6_8 n9_6_8 0 50k
Rx9_6_9 n9_6_9 n10_6_9 1k
Ry9_6_9 n9_6_9 n9_7_9 1k
Rz9_6_9 n9_6_9 n9_6_10 1k
Rg9_6_9 n9_6_9 0 50k
Rx9_6_10 n9_6_10 n10_6_10 1k
Ry9_6_10 n9_6_10 n9_7_10 1k
Rg9_6_10 n9_6_10 0 50k
Rx9_7_0 n9_7_0 n10_7_0 1k
Ry9_7_0 n9_7_0 n9_8_0 1k
Rz9_7_0 n9_7_0 n9_7_1 1k
Rg9_7_0 n9_7_0 0 50k
Rx9_7_1 n9_7_1 n10_7_1 1k
Ry9_7_1 n9_7_1 n9_8_1 1k
Rz9_7_1 n9_7_1 n9_7_2 1k
Rg9_7_1 n9_7_1 0 50k
Rx9_7_2 n9_7_2 n10_7_2 1k
Ry9_7_2 n9_7_2 n9_8_2 1k
Rz9_7_2 n9_7_2 n9_7_3 1k
Rg9_7_2 n9_7_2 0 50k
Rx9_7_3 n9_7_3 n10_7_3 1k
Ry9_7_3 n9_7_3 n9_8_3 1k
Rz9_7_3 n9_7_3 n9_7_4 1k
Rg9_7_3 n9_7_3 0 50k
Rx9_7_4 n9_7_4 n10_7_4 1k
Ry9_7_4 n9_7_4 n9_8_4 1k
Rz9_7_4 n9_7_4 n9_7_5 1k
Rg9_7_4 n9_7_4 0 50k
Rx9_7_5 n9_7_5 n10_7_5 1k
Ry9_7_5 n9_7_5 n9_8_5 1k
Rz9_7_5 n9_7_5 n9_7_6 1k
Rg9_7_5 n9_7_5 0 50k
Rx9_7_6 n9_7_6 n10_7_6 1k
Ry9_7_6 n9_7_6 n9_8_6 1k
Rz9_7_6 n9_7_6 n9_7_7 1k
Rg9_7_6 n9_7_6 0 50k
Rx9_7_7 n9_7_7 n10_7_7 1k
Ry9_7_7 n9_7_7 n9_8_7 1k
Rz9_7_7 n9_7_7 n9_7_8 1k
Rg9_7_7 n9_7_7 0 50k
Rx9_7_8 n9_7_8 n10_7_8 1k
Ry9_7_8 n9_7_8 n9_8_8 1k
Rz9_7_8 n9_7_8 n9_7_9 1k
Rg9_7_8 n9_7_8 0 50k
Rx9_7_9 n9_7_9 n10_7_9 1k
Ry9_7_9 n9_7_9 n9_8_9 1k
Rz9_7_9 n9_7_9 n9_7_10 1k
Rg9_7_9 n9_7_9 0 50k
Rx9_7_10 n9_7_10 n10_7_10 1k
Ry9_7_10 n9_7_10 n9_8_10 1k
Rg9_7_10 n9_7_10 0 50k
Rx9_8_0 n9_8_0 n10_8_0 1k
Ry9_8_0 n9_8_0 n9_9_0 1k
Rz9_8_0 n9_8_0 n9_8_1 1k
Rg9_8_0 n9_8_0 0 50k
Rx9_8_1 n9_8_1 n10_8_1 1k
Ry9_8_1 n9_8_1 n9_9_1 1k
Rz9_8_1 n9_8_1 n9_8_2 1k
Rg9_8_1 n9_8_1 0 50k
Rx9_8_2 n9_8_2 n10_8_2 1k
Ry9_8_2 n9_8_2 n9_9_2 1k
Rz9_8_2 n9_8_2 n9_8_3 1k
Rg9_8_2 n9_8_2 0 50k
Rx9_8_3 n9_8_3 n10_8_3 1k
Ry9_8_3 n9_8_3 n9_9_3 1k
Rz9_8_3 n9_8_3 n9_8_4 1k
Rg9_8_3 n9_8_3 0 50k
Rx9_8_4 n9_8_4 n10_8_4 1k
Ry9_8_4 n9_8_4 n9_9_4 1k
Rz9_8_4 n9_8_4 n9_8_5 1k
Rg9_8_4 n9_8_4 0 50k
Rx9_8_5 n9_8_5 n10_8_5 1k
Ry9_8_5 n9_8_5 n9_9_5 1k
Rz9_8_5 n9_8_5 n9_8_6 1k
Rg9_8_5 n9_8_5 0 50k
Rx9_8_6 n9_8_6 n10_8_6 1k
Ry9_8_6 n9_8_6 n9_9_6 1k
Rz9_8_6 n9_8_6 n9_8_7 1k
Rg9_8_6 n9_8_6 0 50k
Rx9_8_7 n9_8_7 n10_8_7 1k
Ry9_8_7 n9_8_7 n9_9_7 1k
Rz9_8_7 n9_8_7 n9_8_8 1k
Rg9_8_7 n9_8_7 0 50k
Rx9_8_8 n9_8_8 n10_8_8 1k
Ry9_8_8 n9_8_8 n9_9_8 1k
Rz9_8_8 n9_8_8 n9_8_9 1k
Rg9_8_8 n9_8_8 0 50k
Rx9_8_9 n9_8_9 n10_8_9 1k
Ry9_8_9 n9_8_9 n9_9_9 1k
Rz9_8_9 n9_8_9 n9_8_10 1k
Rg9_8_9 n9_8_9 0 50k
Rx9_8_10 n9_8_10 n10_8_10 1k
Ry9_8_10 n9_8_10 n9_9_10 1k
Rg9_8_10 n9_8_10 0 50k
Rx9_9_0 n9_9_0 n10_9_0 1k
Ry9_9_0 n9_9_0 n9_10_0 1k
Rz9_9_0 n9_9_0 n9_9_1 1k
Rg9_9_0 n9_9_0 0 50k
Rx9_9_1 n9_9_1 n10_9_1 1k
Ry9_9_1 n9_9_1 n9_10_1 1k
Rz9_9_1 n9_9_1 n9_9_2 1k
Rg9_9_1 n9_9_1 0 50k
Rx9_9_2 n9_9_2 n10_9_2 1k
Ry9_9_2 n9_9_2 n9_10_2 1k
Rz9_9_2 n9_9_2 n9_9_3 1k
Rg9_9_2 n9_9_2 0 50k
Rx9_9_3 n9_9_3 n10_9_3 1k
Ry9_9_3 n9_9_3 n9_10_3 1k
Rz9_9_3 n9_9_3 n9_9_4 1k
Rg9_9_3 n9_9_3 0 50k
Rx9_9_4 n9_9_4 n10_9_4 1k
Ry9_9_4 n9_9_4 n9_10_4 1k
Rz9_9_4 n9_9_4 n9_9_5 1k
Rg9_9_4 n9_9_4 0 50k
Rx9_9_5 n9_9_5 n10_9_5 1k
Ry9_9_5 n9_9_5 n9_10_5 1k
Rz9_9_5 n9_9_5 n9_9_6 1k
Rg9_9_5 n9_9_5 0 50k
Rx9_9_6 n9_9_6 n10_9_6 1k
Ry9_9_6 n9_9_6 n9_10_6 1k
Rz9_9_6 n9_9_6 n9_9_7 1k
Rg9_9_6 n9_9_6 0 50k
Rx9_9_7 n9_9_7 n10_9_7 1k
Ry9_9_7 n9_9_7 n9_10_7 1k
Rz9_9_7 n9_9_7 n9_9_8 1k
Rg9_9_7 n9_9_7 0 50k
Rx9_9_8 n9_9_8 n10_9_8 1k
Ry9_9_8 n9_9_8 n9_10_8 1k
Rz9_9_8 n9_9_8 n9_9_9 1k
Rg9_9_8 n9_9_8 0 50k
Rx9_9_9 n9_9_9 n10_9_9 1k
Ry9_9_9 n9_9_9 n9_10_9 1k
Rz9_9_9 n9_9_9 n9_9_10 1k
Rg9_9_9 n9_9_9 0 50k
Rx9_9_10 n9_9_10 n10_9_10 1k
Ry9_9_10 n9_9_10 n9_10_10 1k
Rg9_9_10 n9_9_10 0 50k
Rx9_10_0 n9_10_0 n10_10_0 1k
Rz9_10_0 n9_10_0 n9_10_1 1k
Rg9_10_0 n9_10_0 0 50k
Rx9_10_1 n9_10_1 n10_10_1 1k
Rz9_10_1 n9_10_1 n9_10_2 1k
Rg9_10_1 n9_10_1 0 50k
Rx9_10_2 n9_10_2 n10_10_2 1k
Rz9_10_2 n9_10_2 n9_10_3 1k
Rg9_10_2 n9_10_2 0 50k
Rx9_10_3 n9_10_3 n10_10_3 1k
Rz9_10_3 n9_10_3 n9_10_4 1k
Rg9_10_3 n9_10_3 0 50k
Rx9_10_4 n9_10_4 n10_10_4 1k
Rz9_10_4 n9_10_4 n9_10_5 1k
Rg9_10_4 n9_10_4 0 50k
Rx9_10_5 n9_10_5 n10_10_5 1k
Rz9_10_5 n9_10_5 n9_10_6 1k
Rg9_10_5 n9_10_5 0 50k
Rx9_10_6 n9_10_6 n10_10_6 1k
Rz9_10_6 n9_10_6 n9_10_7 1k
Rg9_10_6 n9_10_6 0 50k
Rx9_10_7 n9_10_7 n10_10_7 1k
Rz9_10_7 n9_10_7 n9_10_8 1k
Rg9_10_7 n9_10_7 0 50k
Rx9_10_8 n9_10_8 n10_10_8 1k
Rz9_10_8 n9_10_8 n9_10_9 1k
Rg9_10_8 n9_10_8 0 50k
Rx9_10_9 n9_10_9 n10_10_9 1k
Rz9_10_9 n9_10_9 n9_10_10 1k
Rg9_10_9 n9_10_9 0 50k
Rx9_10_10 n9_10_10 n10_10_10 1k
Rg9_10_10 n9_10_10 0 50k
Ry10_0_0 n10_0_0 n10_1_0 1k
Rz10_0_0 n10_0_0 n10_0_1 1k
Rg10_0_0 n10_0_0 0 50k
Ry10_0_1 n10_0_1 n10_1_1 1k
Rz10_0_1 n10_0_1 n10_0_2 1k
Rg10_0_1 n10_0_1 0 50k
Ry10_0_2 n10_0_2 n10_1_2 1k
Rz10_0_2 n10_0_2 n10_0_3 1k
Rg10_0_2 n10_0_2 0 50k
Ry10_0_3 n10_0_3 n10_1_3 1k
Rz10_0_3 n10_0_3 n10_0_4 1k
Rg10_0_3 n10_0_3 0 50k
Ry10_0_4 n10_0_4 n10_1_4 1k
Rz10_0_4 n10_0_4 n10_0_5 1k
Rg10_0_4 n10_0_4 0 50k
Ry10_0_5 n10_0_5 n10_1_5 1k
Rz10_0_5 n10_0_5 n10_0_6 1k
Rg10_0_5 n10_0_5 0 50k
Ry10_0_6 n10_0_6 n10_1_6 1k
Rz10_0_6 n10_0_6 n10_0_7 1k
Rg10_0_6 n10_0_6 0 50k
Ry10_0_7 n10_0_7 n10_1_7 1k
Rz10_0_7 n10_0_7 n10_0_8 1k
Rg10_0_7 n10_0_7 0 50k
Ry10_0_8 n10_0_8 n10_1_8 1k
Rz10_0_8 n10_0_8 n10_0_9 1k
Rg10_0_8 n10_0_8 0 50k
Ry10_0_9 n10_0_9 n10_1_9 1k
Rz10_0_9 n10_0_9 n10_0_10 1k
Rg10_0_9 n10_0_9 0 50k
Ry10_0_10 n10_0_10 n10_1_10 1k
Rg10_0_10 n10_0_10 0 50k
Ry10_1_0 n10_1_0 n10_2_0 1k
Rz10_1_0 n10_1_0 n10_1_1 1k
Rg10_1_0 n10_1_0 0 50k
Ry10_1_1 n10_1_1 n10_2_1 1k
Rz10_1_1 n10_1_1 n10_1_2 1k
Rg10_1_1 n10_1_1 0 50k
Ry10_1_2 n10_1_2 n10_2_2 1k
Rz10_1_2 n10_1_2 n10_1_3 1k
Rg10_1_2 n10_1_2 0 50k
Ry10_1_3 n10_1_3 n10_2_3 1k
Rz10_1_3 n10_1_3 n10_1_4 1k
Rg10_1_3 n10_1_3 0 50k
Ry10_1_4 n10_1_4 n10_2_4 1k
Rz10_1_4 n10_1_4 n10_1_5 1k
Rg10_1_4 n10_1_4 0 50k
Ry10_1_5 n10_1_5 n10_2_5 1k
Rz10_1_5 n10_1_5 n10_1_6 1k
Rg10_1_5 n10_1_5 0 50k
Ry10_1_6 n10_1_6 n10_2_6 1k
Rz10_1_6 n10_1_6 n10_1_7 1k
Rg10_1_6 n10_1_6 0 50k
Ry10_1_7 n10_1_7 n10_2_7 1k
Rz10_1_7 n10_1_7 n10_1_8 1k
Rg10_1_7 n10_1_7 0 50k
Ry10_1_8 n10_1_8 n10_2_8 1k
Rz10_1_8 n10_1_8 n10_1_9 1k
Rg10_1_8 n10_1_8 0 50k
Ry10_1_9 n10_1_9 n10_2_9 1k
Rz10_1_9 n10_1_9 n10_1_10 1k
Rg10_1_9 n10_1_9 0 50k
Ry10_1_10 n10_1_10 n10_2_10 1k
Rg10_1_10 n10_1_10 0 50k
Ry10_2_0 n10_2_0 n10_3_0 1k
Rz10_2_0 n10_2_0 n10_2_1 1k
Rg10_2_0 n10_2_0 0 50k
Ry10_2_1 n10_2_1 n10_3_1 1k
Rz10_2_1 n10_2_1 n10_2_2 1k
Rg10_2_1 n10_2_1 0 50k
Ry10_2_2 n10_2_2 n10_3_2 1k
Rz10_2_2 n10_2_2 n10_2_3 1k
Rg10_2_2 n10_2_2 0 50k
Ry10_2_3 n10_2_3 n10_3_3 1k
Rz10_2_3 n10_2_3 n10_2_4 1k
Rg10_2_3 n10_2_3 0 50k
Ry10_2_4 n10_2_4 n10_3_4 1k
Rz10_2_4 n10_2_4 n10_2_5 1k
Rg10_2_4 n10_2_4 0 50k
Ry10_2_5 n10_2_5 n10_3_5 1k
Rz10_2_5 n10_2_5 n10_2_6 1k
Rg10_2_5 n10_2_5 0 50k
Ry10_2_6 n10_2_6 n10_3_6 1k
Rz10_2_6 n10_2_6 n10_2_7 1k
Rg10_2_6 n10_2_6 0 50k
Ry10_2_7 n10_2_7 n10_3_7 1k
Rz10_2_7 n10_2_7 n10_2_8 1k
Rg10_2_7 n10_2_7 0 50k
Ry10_2_8 n10_2_8 n10_3_8 1k
Rz10_2_8 n10_2_8 n10_2_9 1k
Rg10_2_8 n10_2_8 0 50k
Ry10_2_9 n10_2_9 n10_3_9 1k
Rz10_2_9 n10_2_9 n10_2_10 1k
Rg10_2_9 n10_2_9 0 50k
Ry10_2_10 n10_2_10 n10_3_10 1k
Rg10_2_10 n10_2_10 0 50k
Ry10_3_0 n10_3_0 n10_4_0 1k
Rz10_3_0 n10_3_0 n10_3_1 1k
Rg10_3_0 n10_3_0 0 50k
Ry10_3_1 n10_3_1 n10_4_1 1k
Rz10_3_1 n10_3_1 n10_3_2 1k
Rg10_3_1 n10_3_1 0 50k
Ry10_3_2 n10_3_2 n10_4_2 1k
Rz10_3_2 n10_3_2 n10_3_3 1k
Rg10_3_2 n10_3_2 0 50k
Ry10_3_3 n10_3_3 n10_4_3 1k
Rz10_3_3 n10_3_3 n10_3_4 1k
Rg10_3_3 n10_3_3 0 50k
Ry10_3_4 n10_3_4 n10_4_4 1k
Rz10_3_4 n10_3_4 n10_3_5 1k
Rg10_3_4 n10_3_4 0 50k
Ry10_3_5 n10_3_5 n10_4_5 1k
Rz10_3_5 n10_3_5 n10_3_6 1k
Rg10_3_5 n10_3_5 0 50k
Ry10_3_6 n10_3_6 n10_4_6 1k
Rz10_3_6 n10_3_6 n10_3_7 1k
Rg10_3_6 n10_3_6 0 50k
Ry10_3_7 n10_3_7 n10_4_7 1k
Rz10_3_7 n10_3_7 n10_3_8 1k
Rg10_3_7 n10_3_7 0 50k
Ry10_3_8 n10_3_8 n10_4_8 1k
Rz10_3_8 n10_3_8 n10_3_9 1k
Rg10_3_8 n10_3_8 0 50k
Ry10_3_9 n10_3_9 n10_4_9 1k
Rz10_3_9 n10_3_9 n10_3_10 1k
Rg10_3_9 n10_3_9 0 50k
Ry10_3_10 n10_3_10 n10_4_10 1k
Rg10_3_10 n10_3_10 0 50k
Ry10_4_0 n10_4_0 n10_5_0 1k
Rz10_4_0 n10_4_0 n10_4_1 1k
Rg10_4_0 n10_4_0 0 50k
Ry10_4_1 n10_4_1 n10_5_1 1k
Rz10_4_1 n10_4_1 n10_4_2 1k
Rg10_4_1 n10_4_1 0 50k
Ry10_4_2 n10_4_2 n10_5_2 1k
Rz10_4_2 n10_4_2 n10_4_3 1k
Rg10_4_2 n10_4_2 0 50k
Ry10_4_3 n10_4_3 n10_5_3 1k
Rz10_4_3 n10_4_3 n10_4_4 1k
Rg10_4_3 n10_4_3 0 50k
Ry10_4_4 n10_4_4 n10_5_4 1k
Rz10_4_4 n10_4_4 n10_4_5 1k
Rg10_4_4 n10_4_4 0 50k
Ry10_4_5 n10_4_5 n10_5_5 1k
Rz10_4_5 n10_4_5 n10_4_6 1k
Rg10_4_5 n10_4_5 0 50k
Ry10_4_6 n10_4_6 n10_5_6 1k
Rz10_4_6 n10_4_6 n10_4_7 1k
Rg10_4_6 n10_4_6 0 50k
Ry10_4_7 n10_4_7 n10_5_7 1k
Rz10_4_7 n10_4_7 n10_4_8 1k
Rg10_4_7 n10_4_7 0 50k
Ry10_4_8 n10_4_8 n10_5_8 1k
Rz10_4_8 n10_4_8 n10_4_9 1k
Rg10_4_8 n10_4_8 0 50k
Ry10_4_9 n10_4_9 n10_5_9 1k
Rz10_4_9 n10_4_9 n10_4_10 1k
Rg10_4_9 n10_4_9 0 50k
Ry10_4_10 n10_4_10 n10_5_10 1k
Rg10_4_10 n10_4_10 0 50k
Ry10_5_0 n10_5_0 n10_6_0 1k
Rz10_5_0 n10_5_0 n10_5_1 1k
Rg10_5_0 n10_5_0 0 50k
Ry10_5_1 n10_5_1 n10_6_1 1k
Rz10_5_1 n10_5_1 n10_5_2 1k
Rg10_5_1 n10_5_1 0 50k
Ry10_5_2 n10_5_2 n10_6_2 1k
Rz10_5_2 n10_5_2 n10_5_3 1k
Rg10_5_2 n10_5_2 0 50k
Ry10_5_3 n10_5_3 n10_6_3 1k
Rz10_5_3 n10_5_3 n10_5_4 1k
Rg10_5_3 n10_5_3 0 50k
Ry10_5_4 n10_5_4 n10_6_4 1k
Rz10_5_4 n10_5_4 n10_5_5 1k
Rg10_5_4 n10_5_4 0 50k
Ry10_5_5 n10_5_5 n10_6_5 1k
Rz10_5_5 n10_5_5 n10_5_6 1k
Rg10_5_5 n10_5_5 0 50k
Ry10_5_6 n10_5_6 n10_6_6 1k
Rz10_5_6 n10_5_6 n10_5_7 1k
Rg10_5_6 n10_5_6 0 50k
Ry10_5_7 n10_5_7 n10_6_7 1k
Rz10_5_7 n10_5_7 n10_5_8 1k
Rg10_5_7 n10_5_7 0 50k
Ry10_5_8 n10_5_8 n10_6_8 1k
Rz10_5_8 n10_5_8 n10_5_9 1k
Rg10_5_8 n10_5_8 0 50k
Ry10_5_9 n10_5_9 n10_6_9 1k
Rz10_5_9 n10_5_9 n10_5_10 1k
Rg10_5_9 n10_5_9 0 50k
Ry10_5_10 n10_5_10 n10_6_10 1k
Rg10_5_10 n10_5_10 0 50k
Ry10_6_0 n10_6_0 n10_7_0 1k
Rz10_6_0 n10_6_0 n10_6_1 1k
Rg10_6_0 n10_6_0 0 50k
Ry10_6_1 n10_6_1 n10_7_1 1k
Rz10_6_1 n10_6_1 n10_6_2 1k
Rg10_6_1 n10_6_1 0 50k
Ry10_6_2 n10_6_2 n10_7_2 1k
Rz10_6_2 n10_6_2 n10_6_3 1k
Rg10_6_2 n10_6_2 0 50k
Ry10_6_3 n10_6_3 n10_7_3 1k
Rz10_6_3 n10_6_3 n10_6_4 1k
Rg10_6_3 n10_6_3 0 50k
Ry10_6_4 n10_6_4 n10_7_4 1k
Rz10_6_4 n10_6_4 n10_6_5 1k
Rg10_6_4 n10_6_4 0 50k
Ry10_6_5 n10_6_5 n10_7_5 1k
Rz10_6_5 n10_6_5 n10_6_6 1k
Rg10_6_5 n10_6_5 0 50k
Ry10_6_6 n10_6_6 n10_7_6 1k
Rz10_6_6 n10_6_6 n10_6_7 1k
Rg10_6_6 n10_6_6 0 50k
Ry10_6_7 n10_6_7 n10_7_7 1k
Rz10_6_7 n10_6_7 n10_6_8 1k
Rg10_6_7 n10_6_7 0 50k
Ry10_6_8 n10_6_8 n10_7_8 1k
Rz10_6_8 n10_6_8 n10_6_9 1k
Rg10_6_8 n10_6_8 0 50k
Ry10_6_9 n10_6_9 n10_7_9 1k
Rz10_6_9 n10_6_9 n10_6_10 1k
Rg10_6_9 n10_6_9 0 50k
Ry10_6_10 n10_6_10 n10_7_10 1k
Rg10_6_10 n10_6_10 0 50k
Ry10_7_0 n10_7_0 n10_8_0 1k
Rz10_7_0 n10_7_0 n10_7_1 1k
Rg10_7_0 n10_7_0 0 50k
Ry10_7_1 n10_7_1 n10_8_1 1k
Rz10_7_1 n10_7_1 n10_7_2 1k
Rg10_7_1 n10_7_1 0 50k
Ry10_7_2 n10_7_2 n10_8_2 1k
Rz10_7_2 n10_7_2 n10_7_3 1k
Rg10_7_2 n10_7_2 0 50k
Ry10_7_3 n10_7_3 n10_8_3 1k
Rz10_7_3 n10_7_3 n10_7_4 1k
Rg10_7_3 n10_7_3 0 50k
Ry10_7_4 n10_7_4 n10_8_4 1k
Rz10_7_4 n10_7_4 n10_7_5 1k
Rg10_7_4 n10_7_4 0 50k
Ry10_7_5 n10_7_5 n10_8_5 1k
Rz10_7_5 n10_7_5 n10_7_6 1k
Rg10_7_5 n10_7_5 0 50k
Ry10_7_6 n10_7_6 n10_8_6 1k
Rz10_7_6 n10_7_6 n10_7_7 1k
Rg10_7_6 n10_7_6 0 50k
Ry10_7_7 n10_7_7 n10_8_7 1k
Rz10_7_7 n10_7_7 n10_7_8 1k
Rg10_7_7 n10_7_7 0 50k
Ry10_7_8 n10_7_8 n10_8_8 1k
Rz10_7_8 n10_7_8 n10_7_9 1k
Rg10_7_8 n10_7_8 0 50k
Ry10_7_9 n10_7_9 n10_8_9 1k
Rz10_7_9 n10_7_9 n10_7_10 1k
Rg10_7_9 n10_7_9 0 50k
Ry10_7_10 n10_7_10 n10_8_10 1k
Rg10_7_10 n10_7_10 0 50k
Ry10_8_0 n10_8_0 n10_9_0 1k
Rz10_8_0 n10_8_0 n10_8_1 1k
Rg10_8_0 n10_8_0 0 50k
Ry10_8_1 n10_8_1 n10_9_1 1k
Rz10_8_1 n10_8_1 n10_8_2 1k
Rg10_8_1 n10_8_1 0 50k
Ry10_8_2 n10_8_2 n10_9_2 1k
Rz10_8_2 n10_8_2 n10_8_3 1k
Rg10_8_2 n10_8_2 0 50k
Ry10_8_3 n10_8_3 n10_9_3 1k
Rz10_8_3 n10_8_3 n10_8_4 1k
Rg10_8_3 n10_8_3 0 50k
Ry10_8_4 n10_8_4 n10_9_4 1k
Rz10_8_4 n10_8_4 n10_8_5 1k
Rg10_8_4 n10_8_4 0 50k
Ry10_8_5 n10_8_5 n10_9_5 1k
Rz10_8_5 n10_8_5 n10_8_6 1k
Rg10_8_5 n10_8_5 0 50k
Ry10_8_6 n10_8_6 n10_9_6 1k
Rz10_8_6 n10_8_6 n10_8_7 1k
Rg10_8_6 n10_8_6 0 50k
Ry10_8_7 n10_8_7 n10_9_7 1k
Rz10_8_7 n10_8_7 n10_8_8 1k
Rg10_8_7 n10_8_7 0 50k
Ry10_8_8 n10_8_8 n10_9_8 1k
Rz10_8_8 n10_8_8 n10_8_9 1k
Rg10_8_8 n10_8_8 0 50k
Ry10_8_9 n10_8_9 n10_9_9 1k
Rz10_8_9 n10_8_9 n10_8_10 1k
Rg10_8_9 n10_8_9 0 50k
Ry10_8_10 n10_8_10 n10_9_10 1k
Rg10_8_10 n10_8_10 0 50k
Ry10_9_0 n10_9_0 n10_10_0 1k
Rz10_9_0 n10_9_0 n10_9_1 1k
Rg10_9_0 n10_9_0 0 50k
Ry10_9_1 n10_9_1 n10_10_1 1k
Rz10_9_1 n10_9_1 n10_9_2 1k
Rg10_9_1 n10_9_1 0 50k
Ry10_9_2 n10_9_2 n10_10_2 1k
Rz10_9_2 n10_9_2 n10_9_3 1k
Rg10_9_2 n10_9_2 0 50k
Ry10_9_3 n10_9_3 n10_10_3 1k
Rz10_9_3 n10_9_3 n10_9_4 1k
Rg10_9_3 n10_9_3 0 50k
Ry10_9_4 n10_9_4 n10_10_4 1k
Rz10_9_4 n10_9_4 n10_9_5 1k
Rg10_9_4 n10_9_4 0 50k
Ry10_9_5 n10_9_5 n10_10_5 1k
Rz10_9_5 n10_9_5 n10_9_6 1k
Rg10_9_5 n10_9_5 0 50k
Ry10_9_6 n10_9_6 n10_10_6 1k
Rz10_9_6 n10_9_6 n10_9_7 1k
Rg10_9_6 n10_9_6 0 50k
Ry10_9_7 n10_9_7 n10_10_7 1k
Rz10_9_7 n10_9_7 n10_9_8 1k
Rg10_9_7 n10_9_7 0 50k
Ry10_9_8 n10_9_8 n10_10_8 1k
Rz10_9_8 n10_9_8 n10_9_9 1k
Rg10_9_8 n10_9_8 0 50k
Ry10_9_9 n10_9_9 n10_10_9 1k
Rz10_9_9 n10_9_9 n10_9_10 1k
Rg10_9_9 n10_9_9 0 50k
Ry10_9_10 n10_9_10 n10_10_10 1k
Rg10_9_10 n10_9_10 0 50k
Rz10_10_0 n10_10_0 n10_10_1 1k
Rg10_10_0 n10_10_0 0 50k
Rz10_10_1 n10_10_1 n10_10_2 1k
Rg10_10_1 n10_10_1 0 50k
Rz10_10_2 n10_10_2 n10_10_3 1k
Rg10_10_2 n10_10_2 0 50k
Rz10_10_3 n10_10_3 n10_10_4 1k
Rg10_10_3 n10_10_3 0 50k
Rz10_10_4 n10_10_4 n10_10_5 1k
Rg10_10_4 n10_10_4 0 50k
Rz10_10_5 n10_10_5 n10_10_6 1k
Rg10_10_5 n10_10_5 0 50k
Rz10_10_6 n10_10_6 n10_10_7 1k
Rg10_10_6 n10_10_6 0 50k
Rz10_10_7 n10_10_7 n10_10_8 1k
Rg10_10_7 n10_10_7 0 50k
Rz10_10_8 n10_10_8 n10_10_9 1k
Rg10_10_8 n10_10_8 0 50k
Rz10_10_9 n10_10_9 n10_10_10 1k
Rg10_10_9 n10_10_9 0 50k
Rg10_10_10 n10_10_10 0 50k
.op
.end
