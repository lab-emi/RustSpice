RC mesh 16x16, step one tenth of the node RC time constant, 3000 steps
* bench.id: perf_med_rc_mesh_fine_tran_16x16
* bench.group: performance
* bench.title: RC mesh 16x16, step one tenth of the node RC time constant, 3000 steps
* bench.probes: v(n0_0), v(n8_8), v(n15_15), i(v1)
* bench.tol.norm: 2e-3
* bench.expect: match
* bench.oracle: tran_lti
* bench.ref: reltol=1e-6 abstol=1e-15 vntol=1e-9
* bench.ref.tmax: 10p
* bench.ng.solver: both
* bench.timing: no
* bench.size: 258
* bench.est_rss_mib: 20
* bench.tags: linear, tran, mesh, medium, silent_risk
* bench.note: same mesh family as perf_med_rc_mesh_tran_12x12 but with the step small against the node RC time constant (large C/h on the diagonal) at 258 unknowns; tstop is 3000.5 steps so the last step is a legitimate half step; timing is not trusted because the answer is wrong. Onset (same mesh family, 10 ps step, other sizes measured against the converged ngspice and the tran_lti oracle): 6x6 (38 unknowns) is fine at 4e-5, 7x7 (51 unknowns) is at 1.4e-3, 8x8 (66 unknowns) at 0.13 and 10x10 at 2.6e54, all on the UnrolledSymbolic tier, while 36x36 (1298 unknowns, FaerSupernodal tier) passes at 1.3e-4: the divergence is specific to the unrolled-LU tier from about 50 unknowns on, whatever the size threshold in the slug text says. benchmarks/proposed-fixes/README.md (RC-lu-pivot) traces it to the frozen pivot order of that LU; that analysis was not re-run here.
V1 in 0 PULSE(0 1 100p 1n 1n 4n 10n)
Rin in n0_0 100
C0_0 n0_0 0 1p
Rh0_0 n0_0 n0_1 100
Rv0_0 n0_0 n1_0 100
C0_1 n0_1 0 1p
Rh0_1 n0_1 n0_2 100
Rv0_1 n0_1 n1_1 100
C0_2 n0_2 0 1p
Rh0_2 n0_2 n0_3 100
Rv0_2 n0_2 n1_2 100
C0_3 n0_3 0 1p
Rh0_3 n0_3 n0_4 100
Rv0_3 n0_3 n1_3 100
C0_4 n0_4 0 1p
Rh0_4 n0_4 n0_5 100
Rv0_4 n0_4 n1_4 100
C0_5 n0_5 0 1p
Rh0_5 n0_5 n0_6 100
Rv0_5 n0_5 n1_5 100
C0_6 n0_6 0 1p
Rh0_6 n0_6 n0_7 100
Rv0_6 n0_6 n1_6 100
C0_7 n0_7 0 1p
Rh0_7 n0_7 n0_8 100
Rv0_7 n0_7 n1_7 100
C0_8 n0_8 0 1p
Rh0_8 n0_8 n0_9 100
Rv0_8 n0_8 n1_8 100
C0_9 n0_9 0 1p
Rh0_9 n0_9 n0_10 100
Rv0_9 n0_9 n1_9 100
C0_10 n0_10 0 1p
Rh0_10 n0_10 n0_11 100
Rv0_10 n0_10 n1_10 100
C0_11 n0_11 0 1p
Rh0_11 n0_11 n0_12 100
Rv0_11 n0_11 n1_11 100
C0_12 n0_12 0 1p
Rh0_12 n0_12 n0_13 100
Rv0_12 n0_12 n1_12 100
C0_13 n0_13 0 1p
Rh0_13 n0_13 n0_14 100
Rv0_13 n0_13 n1_13 100
C0_14 n0_14 0 1p
Rh0_14 n0_14 n0_15 100
Rv0_14 n0_14 n1_14 100
C0_15 n0_15 0 1p
Rv0_15 n0_15 n1_15 100
C1_0 n1_0 0 1p
Rh1_0 n1_0 n1_1 100
Rv1_0 n1_0 n2_0 100
C1_1 n1_1 0 1p
Rh1_1 n1_1 n1_2 100
Rv1_1 n1_1 n2_1 100
C1_2 n1_2 0 1p
Rh1_2 n1_2 n1_3 100
Rv1_2 n1_2 n2_2 100
C1_3 n1_3 0 1p
Rh1_3 n1_3 n1_4 100
Rv1_3 n1_3 n2_3 100
C1_4 n1_4 0 1p
Rh1_4 n1_4 n1_5 100
Rv1_4 n1_4 n2_4 100
C1_5 n1_5 0 1p
Rh1_5 n1_5 n1_6 100
Rv1_5 n1_5 n2_5 100
C1_6 n1_6 0 1p
Rh1_6 n1_6 n1_7 100
Rv1_6 n1_6 n2_6 100
C1_7 n1_7 0 1p
Rh1_7 n1_7 n1_8 100
Rv1_7 n1_7 n2_7 100
C1_8 n1_8 0 1p
Rh1_8 n1_8 n1_9 100
Rv1_8 n1_8 n2_8 100
C1_9 n1_9 0 1p
Rh1_9 n1_9 n1_10 100
Rv1_9 n1_9 n2_9 100
C1_10 n1_10 0 1p
Rh1_10 n1_10 n1_11 100
Rv1_10 n1_10 n2_10 100
C1_11 n1_11 0 1p
Rh1_11 n1_11 n1_12 100
Rv1_11 n1_11 n2_11 100
C1_12 n1_12 0 1p
Rh1_12 n1_12 n1_13 100
Rv1_12 n1_12 n2_12 100
C1_13 n1_13 0 1p
Rh1_13 n1_13 n1_14 100
Rv1_13 n1_13 n2_13 100
C1_14 n1_14 0 1p
Rh1_14 n1_14 n1_15 100
Rv1_14 n1_14 n2_14 100
C1_15 n1_15 0 1p
Rv1_15 n1_15 n2_15 100
C2_0 n2_0 0 1p
Rh2_0 n2_0 n2_1 100
Rv2_0 n2_0 n3_0 100
C2_1 n2_1 0 1p
Rh2_1 n2_1 n2_2 100
Rv2_1 n2_1 n3_1 100
C2_2 n2_2 0 1p
Rh2_2 n2_2 n2_3 100
Rv2_2 n2_2 n3_2 100
C2_3 n2_3 0 1p
Rh2_3 n2_3 n2_4 100
Rv2_3 n2_3 n3_3 100
C2_4 n2_4 0 1p
Rh2_4 n2_4 n2_5 100
Rv2_4 n2_4 n3_4 100
C2_5 n2_5 0 1p
Rh2_5 n2_5 n2_6 100
Rv2_5 n2_5 n3_5 100
C2_6 n2_6 0 1p
Rh2_6 n2_6 n2_7 100
Rv2_6 n2_6 n3_6 100
C2_7 n2_7 0 1p
Rh2_7 n2_7 n2_8 100
Rv2_7 n2_7 n3_7 100
C2_8 n2_8 0 1p
Rh2_8 n2_8 n2_9 100
Rv2_8 n2_8 n3_8 100
C2_9 n2_9 0 1p
Rh2_9 n2_9 n2_10 100
Rv2_9 n2_9 n3_9 100
C2_10 n2_10 0 1p
Rh2_10 n2_10 n2_11 100
Rv2_10 n2_10 n3_10 100
C2_11 n2_11 0 1p
Rh2_11 n2_11 n2_12 100
Rv2_11 n2_11 n3_11 100
C2_12 n2_12 0 1p
Rh2_12 n2_12 n2_13 100
Rv2_12 n2_12 n3_12 100
C2_13 n2_13 0 1p
Rh2_13 n2_13 n2_14 100
Rv2_13 n2_13 n3_13 100
C2_14 n2_14 0 1p
Rh2_14 n2_14 n2_15 100
Rv2_14 n2_14 n3_14 100
C2_15 n2_15 0 1p
Rv2_15 n2_15 n3_15 100
C3_0 n3_0 0 1p
Rh3_0 n3_0 n3_1 100
Rv3_0 n3_0 n4_0 100
C3_1 n3_1 0 1p
Rh3_1 n3_1 n3_2 100
Rv3_1 n3_1 n4_1 100
C3_2 n3_2 0 1p
Rh3_2 n3_2 n3_3 100
Rv3_2 n3_2 n4_2 100
C3_3 n3_3 0 1p
Rh3_3 n3_3 n3_4 100
Rv3_3 n3_3 n4_3 100
C3_4 n3_4 0 1p
Rh3_4 n3_4 n3_5 100
Rv3_4 n3_4 n4_4 100
C3_5 n3_5 0 1p
Rh3_5 n3_5 n3_6 100
Rv3_5 n3_5 n4_5 100
C3_6 n3_6 0 1p
Rh3_6 n3_6 n3_7 100
Rv3_6 n3_6 n4_6 100
C3_7 n3_7 0 1p
Rh3_7 n3_7 n3_8 100
Rv3_7 n3_7 n4_7 100
C3_8 n3_8 0 1p
Rh3_8 n3_8 n3_9 100
Rv3_8 n3_8 n4_8 100
C3_9 n3_9 0 1p
Rh3_9 n3_9 n3_10 100
Rv3_9 n3_9 n4_9 100
C3_10 n3_10 0 1p
Rh3_10 n3_10 n3_11 100
Rv3_10 n3_10 n4_10 100
C3_11 n3_11 0 1p
Rh3_11 n3_11 n3_12 100
Rv3_11 n3_11 n4_11 100
C3_12 n3_12 0 1p
Rh3_12 n3_12 n3_13 100
Rv3_12 n3_12 n4_12 100
C3_13 n3_13 0 1p
Rh3_13 n3_13 n3_14 100
Rv3_13 n3_13 n4_13 100
C3_14 n3_14 0 1p
Rh3_14 n3_14 n3_15 100
Rv3_14 n3_14 n4_14 100
C3_15 n3_15 0 1p
Rv3_15 n3_15 n4_15 100
C4_0 n4_0 0 1p
Rh4_0 n4_0 n4_1 100
Rv4_0 n4_0 n5_0 100
C4_1 n4_1 0 1p
Rh4_1 n4_1 n4_2 100
Rv4_1 n4_1 n5_1 100
C4_2 n4_2 0 1p
Rh4_2 n4_2 n4_3 100
Rv4_2 n4_2 n5_2 100
C4_3 n4_3 0 1p
Rh4_3 n4_3 n4_4 100
Rv4_3 n4_3 n5_3 100
C4_4 n4_4 0 1p
Rh4_4 n4_4 n4_5 100
Rv4_4 n4_4 n5_4 100
C4_5 n4_5 0 1p
Rh4_5 n4_5 n4_6 100
Rv4_5 n4_5 n5_5 100
C4_6 n4_6 0 1p
Rh4_6 n4_6 n4_7 100
Rv4_6 n4_6 n5_6 100
C4_7 n4_7 0 1p
Rh4_7 n4_7 n4_8 100
Rv4_7 n4_7 n5_7 100
C4_8 n4_8 0 1p
Rh4_8 n4_8 n4_9 100
Rv4_8 n4_8 n5_8 100
C4_9 n4_9 0 1p
Rh4_9 n4_9 n4_10 100
Rv4_9 n4_9 n5_9 100
C4_10 n4_10 0 1p
Rh4_10 n4_10 n4_11 100
Rv4_10 n4_10 n5_10 100
C4_11 n4_11 0 1p
Rh4_11 n4_11 n4_12 100
Rv4_11 n4_11 n5_11 100
C4_12 n4_12 0 1p
Rh4_12 n4_12 n4_13 100
Rv4_12 n4_12 n5_12 100
C4_13 n4_13 0 1p
Rh4_13 n4_13 n4_14 100
Rv4_13 n4_13 n5_13 100
C4_14 n4_14 0 1p
Rh4_14 n4_14 n4_15 100
Rv4_14 n4_14 n5_14 100
C4_15 n4_15 0 1p
Rv4_15 n4_15 n5_15 100
C5_0 n5_0 0 1p
Rh5_0 n5_0 n5_1 100
Rv5_0 n5_0 n6_0 100
C5_1 n5_1 0 1p
Rh5_1 n5_1 n5_2 100
Rv5_1 n5_1 n6_1 100
C5_2 n5_2 0 1p
Rh5_2 n5_2 n5_3 100
Rv5_2 n5_2 n6_2 100
C5_3 n5_3 0 1p
Rh5_3 n5_3 n5_4 100
Rv5_3 n5_3 n6_3 100
C5_4 n5_4 0 1p
Rh5_4 n5_4 n5_5 100
Rv5_4 n5_4 n6_4 100
C5_5 n5_5 0 1p
Rh5_5 n5_5 n5_6 100
Rv5_5 n5_5 n6_5 100
C5_6 n5_6 0 1p
Rh5_6 n5_6 n5_7 100
Rv5_6 n5_6 n6_6 100
C5_7 n5_7 0 1p
Rh5_7 n5_7 n5_8 100
Rv5_7 n5_7 n6_7 100
C5_8 n5_8 0 1p
Rh5_8 n5_8 n5_9 100
Rv5_8 n5_8 n6_8 100
C5_9 n5_9 0 1p
Rh5_9 n5_9 n5_10 100
Rv5_9 n5_9 n6_9 100
C5_10 n5_10 0 1p
Rh5_10 n5_10 n5_11 100
Rv5_10 n5_10 n6_10 100
C5_11 n5_11 0 1p
Rh5_11 n5_11 n5_12 100
Rv5_11 n5_11 n6_11 100
C5_12 n5_12 0 1p
Rh5_12 n5_12 n5_13 100
Rv5_12 n5_12 n6_12 100
C5_13 n5_13 0 1p
Rh5_13 n5_13 n5_14 100
Rv5_13 n5_13 n6_13 100
C5_14 n5_14 0 1p
Rh5_14 n5_14 n5_15 100
Rv5_14 n5_14 n6_14 100
C5_15 n5_15 0 1p
Rv5_15 n5_15 n6_15 100
C6_0 n6_0 0 1p
Rh6_0 n6_0 n6_1 100
Rv6_0 n6_0 n7_0 100
C6_1 n6_1 0 1p
Rh6_1 n6_1 n6_2 100
Rv6_1 n6_1 n7_1 100
C6_2 n6_2 0 1p
Rh6_2 n6_2 n6_3 100
Rv6_2 n6_2 n7_2 100
C6_3 n6_3 0 1p
Rh6_3 n6_3 n6_4 100
Rv6_3 n6_3 n7_3 100
C6_4 n6_4 0 1p
Rh6_4 n6_4 n6_5 100
Rv6_4 n6_4 n7_4 100
C6_5 n6_5 0 1p
Rh6_5 n6_5 n6_6 100
Rv6_5 n6_5 n7_5 100
C6_6 n6_6 0 1p
Rh6_6 n6_6 n6_7 100
Rv6_6 n6_6 n7_6 100
C6_7 n6_7 0 1p
Rh6_7 n6_7 n6_8 100
Rv6_7 n6_7 n7_7 100
C6_8 n6_8 0 1p
Rh6_8 n6_8 n6_9 100
Rv6_8 n6_8 n7_8 100
C6_9 n6_9 0 1p
Rh6_9 n6_9 n6_10 100
Rv6_9 n6_9 n7_9 100
C6_10 n6_10 0 1p
Rh6_10 n6_10 n6_11 100
Rv6_10 n6_10 n7_10 100
C6_11 n6_11 0 1p
Rh6_11 n6_11 n6_12 100
Rv6_11 n6_11 n7_11 100
C6_12 n6_12 0 1p
Rh6_12 n6_12 n6_13 100
Rv6_12 n6_12 n7_12 100
C6_13 n6_13 0 1p
Rh6_13 n6_13 n6_14 100
Rv6_13 n6_13 n7_13 100
C6_14 n6_14 0 1p
Rh6_14 n6_14 n6_15 100
Rv6_14 n6_14 n7_14 100
C6_15 n6_15 0 1p
Rv6_15 n6_15 n7_15 100
C7_0 n7_0 0 1p
Rh7_0 n7_0 n7_1 100
Rv7_0 n7_0 n8_0 100
C7_1 n7_1 0 1p
Rh7_1 n7_1 n7_2 100
Rv7_1 n7_1 n8_1 100
C7_2 n7_2 0 1p
Rh7_2 n7_2 n7_3 100
Rv7_2 n7_2 n8_2 100
C7_3 n7_3 0 1p
Rh7_3 n7_3 n7_4 100
Rv7_3 n7_3 n8_3 100
C7_4 n7_4 0 1p
Rh7_4 n7_4 n7_5 100
Rv7_4 n7_4 n8_4 100
C7_5 n7_5 0 1p
Rh7_5 n7_5 n7_6 100
Rv7_5 n7_5 n8_5 100
C7_6 n7_6 0 1p
Rh7_6 n7_6 n7_7 100
Rv7_6 n7_6 n8_6 100
C7_7 n7_7 0 1p
Rh7_7 n7_7 n7_8 100
Rv7_7 n7_7 n8_7 100
C7_8 n7_8 0 1p
Rh7_8 n7_8 n7_9 100
Rv7_8 n7_8 n8_8 100
C7_9 n7_9 0 1p
Rh7_9 n7_9 n7_10 100
Rv7_9 n7_9 n8_9 100
C7_10 n7_10 0 1p
Rh7_10 n7_10 n7_11 100
Rv7_10 n7_10 n8_10 100
C7_11 n7_11 0 1p
Rh7_11 n7_11 n7_12 100
Rv7_11 n7_11 n8_11 100
C7_12 n7_12 0 1p
Rh7_12 n7_12 n7_13 100
Rv7_12 n7_12 n8_12 100
C7_13 n7_13 0 1p
Rh7_13 n7_13 n7_14 100
Rv7_13 n7_13 n8_13 100
C7_14 n7_14 0 1p
Rh7_14 n7_14 n7_15 100
Rv7_14 n7_14 n8_14 100
C7_15 n7_15 0 1p
Rv7_15 n7_15 n8_15 100
C8_0 n8_0 0 1p
Rh8_0 n8_0 n8_1 100
Rv8_0 n8_0 n9_0 100
C8_1 n8_1 0 1p
Rh8_1 n8_1 n8_2 100
Rv8_1 n8_1 n9_1 100
C8_2 n8_2 0 1p
Rh8_2 n8_2 n8_3 100
Rv8_2 n8_2 n9_2 100
C8_3 n8_3 0 1p
Rh8_3 n8_3 n8_4 100
Rv8_3 n8_3 n9_3 100
C8_4 n8_4 0 1p
Rh8_4 n8_4 n8_5 100
Rv8_4 n8_4 n9_4 100
C8_5 n8_5 0 1p
Rh8_5 n8_5 n8_6 100
Rv8_5 n8_5 n9_5 100
C8_6 n8_6 0 1p
Rh8_6 n8_6 n8_7 100
Rv8_6 n8_6 n9_6 100
C8_7 n8_7 0 1p
Rh8_7 n8_7 n8_8 100
Rv8_7 n8_7 n9_7 100
C8_8 n8_8 0 1p
Rh8_8 n8_8 n8_9 100
Rv8_8 n8_8 n9_8 100
C8_9 n8_9 0 1p
Rh8_9 n8_9 n8_10 100
Rv8_9 n8_9 n9_9 100
C8_10 n8_10 0 1p
Rh8_10 n8_10 n8_11 100
Rv8_10 n8_10 n9_10 100
C8_11 n8_11 0 1p
Rh8_11 n8_11 n8_12 100
Rv8_11 n8_11 n9_11 100
C8_12 n8_12 0 1p
Rh8_12 n8_12 n8_13 100
Rv8_12 n8_12 n9_12 100
C8_13 n8_13 0 1p
Rh8_13 n8_13 n8_14 100
Rv8_13 n8_13 n9_13 100
C8_14 n8_14 0 1p
Rh8_14 n8_14 n8_15 100
Rv8_14 n8_14 n9_14 100
C8_15 n8_15 0 1p
Rv8_15 n8_15 n9_15 100
C9_0 n9_0 0 1p
Rh9_0 n9_0 n9_1 100
Rv9_0 n9_0 n10_0 100
C9_1 n9_1 0 1p
Rh9_1 n9_1 n9_2 100
Rv9_1 n9_1 n10_1 100
C9_2 n9_2 0 1p
Rh9_2 n9_2 n9_3 100
Rv9_2 n9_2 n10_2 100
C9_3 n9_3 0 1p
Rh9_3 n9_3 n9_4 100
Rv9_3 n9_3 n10_3 100
C9_4 n9_4 0 1p
Rh9_4 n9_4 n9_5 100
Rv9_4 n9_4 n10_4 100
C9_5 n9_5 0 1p
Rh9_5 n9_5 n9_6 100
Rv9_5 n9_5 n10_5 100
C9_6 n9_6 0 1p
Rh9_6 n9_6 n9_7 100
Rv9_6 n9_6 n10_6 100
C9_7 n9_7 0 1p
Rh9_7 n9_7 n9_8 100
Rv9_7 n9_7 n10_7 100
C9_8 n9_8 0 1p
Rh9_8 n9_8 n9_9 100
Rv9_8 n9_8 n10_8 100
C9_9 n9_9 0 1p
Rh9_9 n9_9 n9_10 100
Rv9_9 n9_9 n10_9 100
C9_10 n9_10 0 1p
Rh9_10 n9_10 n9_11 100
Rv9_10 n9_10 n10_10 100
C9_11 n9_11 0 1p
Rh9_11 n9_11 n9_12 100
Rv9_11 n9_11 n10_11 100
C9_12 n9_12 0 1p
Rh9_12 n9_12 n9_13 100
Rv9_12 n9_12 n10_12 100
C9_13 n9_13 0 1p
Rh9_13 n9_13 n9_14 100
Rv9_13 n9_13 n10_13 100
C9_14 n9_14 0 1p
Rh9_14 n9_14 n9_15 100
Rv9_14 n9_14 n10_14 100
C9_15 n9_15 0 1p
Rv9_15 n9_15 n10_15 100
C10_0 n10_0 0 1p
Rh10_0 n10_0 n10_1 100
Rv10_0 n10_0 n11_0 100
C10_1 n10_1 0 1p
Rh10_1 n10_1 n10_2 100
Rv10_1 n10_1 n11_1 100
C10_2 n10_2 0 1p
Rh10_2 n10_2 n10_3 100
Rv10_2 n10_2 n11_2 100
C10_3 n10_3 0 1p
Rh10_3 n10_3 n10_4 100
Rv10_3 n10_3 n11_3 100
C10_4 n10_4 0 1p
Rh10_4 n10_4 n10_5 100
Rv10_4 n10_4 n11_4 100
C10_5 n10_5 0 1p
Rh10_5 n10_5 n10_6 100
Rv10_5 n10_5 n11_5 100
C10_6 n10_6 0 1p
Rh10_6 n10_6 n10_7 100
Rv10_6 n10_6 n11_6 100
C10_7 n10_7 0 1p
Rh10_7 n10_7 n10_8 100
Rv10_7 n10_7 n11_7 100
C10_8 n10_8 0 1p
Rh10_8 n10_8 n10_9 100
Rv10_8 n10_8 n11_8 100
C10_9 n10_9 0 1p
Rh10_9 n10_9 n10_10 100
Rv10_9 n10_9 n11_9 100
C10_10 n10_10 0 1p
Rh10_10 n10_10 n10_11 100
Rv10_10 n10_10 n11_10 100
C10_11 n10_11 0 1p
Rh10_11 n10_11 n10_12 100
Rv10_11 n10_11 n11_11 100
C10_12 n10_12 0 1p
Rh10_12 n10_12 n10_13 100
Rv10_12 n10_12 n11_12 100
C10_13 n10_13 0 1p
Rh10_13 n10_13 n10_14 100
Rv10_13 n10_13 n11_13 100
C10_14 n10_14 0 1p
Rh10_14 n10_14 n10_15 100
Rv10_14 n10_14 n11_14 100
C10_15 n10_15 0 1p
Rv10_15 n10_15 n11_15 100
C11_0 n11_0 0 1p
Rh11_0 n11_0 n11_1 100
Rv11_0 n11_0 n12_0 100
C11_1 n11_1 0 1p
Rh11_1 n11_1 n11_2 100
Rv11_1 n11_1 n12_1 100
C11_2 n11_2 0 1p
Rh11_2 n11_2 n11_3 100
Rv11_2 n11_2 n12_2 100
C11_3 n11_3 0 1p
Rh11_3 n11_3 n11_4 100
Rv11_3 n11_3 n12_3 100
C11_4 n11_4 0 1p
Rh11_4 n11_4 n11_5 100
Rv11_4 n11_4 n12_4 100
C11_5 n11_5 0 1p
Rh11_5 n11_5 n11_6 100
Rv11_5 n11_5 n12_5 100
C11_6 n11_6 0 1p
Rh11_6 n11_6 n11_7 100
Rv11_6 n11_6 n12_6 100
C11_7 n11_7 0 1p
Rh11_7 n11_7 n11_8 100
Rv11_7 n11_7 n12_7 100
C11_8 n11_8 0 1p
Rh11_8 n11_8 n11_9 100
Rv11_8 n11_8 n12_8 100
C11_9 n11_9 0 1p
Rh11_9 n11_9 n11_10 100
Rv11_9 n11_9 n12_9 100
C11_10 n11_10 0 1p
Rh11_10 n11_10 n11_11 100
Rv11_10 n11_10 n12_10 100
C11_11 n11_11 0 1p
Rh11_11 n11_11 n11_12 100
Rv11_11 n11_11 n12_11 100
C11_12 n11_12 0 1p
Rh11_12 n11_12 n11_13 100
Rv11_12 n11_12 n12_12 100
C11_13 n11_13 0 1p
Rh11_13 n11_13 n11_14 100
Rv11_13 n11_13 n12_13 100
C11_14 n11_14 0 1p
Rh11_14 n11_14 n11_15 100
Rv11_14 n11_14 n12_14 100
C11_15 n11_15 0 1p
Rv11_15 n11_15 n12_15 100
C12_0 n12_0 0 1p
Rh12_0 n12_0 n12_1 100
Rv12_0 n12_0 n13_0 100
C12_1 n12_1 0 1p
Rh12_1 n12_1 n12_2 100
Rv12_1 n12_1 n13_1 100
C12_2 n12_2 0 1p
Rh12_2 n12_2 n12_3 100
Rv12_2 n12_2 n13_2 100
C12_3 n12_3 0 1p
Rh12_3 n12_3 n12_4 100
Rv12_3 n12_3 n13_3 100
C12_4 n12_4 0 1p
Rh12_4 n12_4 n12_5 100
Rv12_4 n12_4 n13_4 100
C12_5 n12_5 0 1p
Rh12_5 n12_5 n12_6 100
Rv12_5 n12_5 n13_5 100
C12_6 n12_6 0 1p
Rh12_6 n12_6 n12_7 100
Rv12_6 n12_6 n13_6 100
C12_7 n12_7 0 1p
Rh12_7 n12_7 n12_8 100
Rv12_7 n12_7 n13_7 100
C12_8 n12_8 0 1p
Rh12_8 n12_8 n12_9 100
Rv12_8 n12_8 n13_8 100
C12_9 n12_9 0 1p
Rh12_9 n12_9 n12_10 100
Rv12_9 n12_9 n13_9 100
C12_10 n12_10 0 1p
Rh12_10 n12_10 n12_11 100
Rv12_10 n12_10 n13_10 100
C12_11 n12_11 0 1p
Rh12_11 n12_11 n12_12 100
Rv12_11 n12_11 n13_11 100
C12_12 n12_12 0 1p
Rh12_12 n12_12 n12_13 100
Rv12_12 n12_12 n13_12 100
C12_13 n12_13 0 1p
Rh12_13 n12_13 n12_14 100
Rv12_13 n12_13 n13_13 100
C12_14 n12_14 0 1p
Rh12_14 n12_14 n12_15 100
Rv12_14 n12_14 n13_14 100
C12_15 n12_15 0 1p
Rv12_15 n12_15 n13_15 100
C13_0 n13_0 0 1p
Rh13_0 n13_0 n13_1 100
Rv13_0 n13_0 n14_0 100
C13_1 n13_1 0 1p
Rh13_1 n13_1 n13_2 100
Rv13_1 n13_1 n14_1 100
C13_2 n13_2 0 1p
Rh13_2 n13_2 n13_3 100
Rv13_2 n13_2 n14_2 100
C13_3 n13_3 0 1p
Rh13_3 n13_3 n13_4 100
Rv13_3 n13_3 n14_3 100
C13_4 n13_4 0 1p
Rh13_4 n13_4 n13_5 100
Rv13_4 n13_4 n14_4 100
C13_5 n13_5 0 1p
Rh13_5 n13_5 n13_6 100
Rv13_5 n13_5 n14_5 100
C13_6 n13_6 0 1p
Rh13_6 n13_6 n13_7 100
Rv13_6 n13_6 n14_6 100
C13_7 n13_7 0 1p
Rh13_7 n13_7 n13_8 100
Rv13_7 n13_7 n14_7 100
C13_8 n13_8 0 1p
Rh13_8 n13_8 n13_9 100
Rv13_8 n13_8 n14_8 100
C13_9 n13_9 0 1p
Rh13_9 n13_9 n13_10 100
Rv13_9 n13_9 n14_9 100
C13_10 n13_10 0 1p
Rh13_10 n13_10 n13_11 100
Rv13_10 n13_10 n14_10 100
C13_11 n13_11 0 1p
Rh13_11 n13_11 n13_12 100
Rv13_11 n13_11 n14_11 100
C13_12 n13_12 0 1p
Rh13_12 n13_12 n13_13 100
Rv13_12 n13_12 n14_12 100
C13_13 n13_13 0 1p
Rh13_13 n13_13 n13_14 100
Rv13_13 n13_13 n14_13 100
C13_14 n13_14 0 1p
Rh13_14 n13_14 n13_15 100
Rv13_14 n13_14 n14_14 100
C13_15 n13_15 0 1p
Rv13_15 n13_15 n14_15 100
C14_0 n14_0 0 1p
Rh14_0 n14_0 n14_1 100
Rv14_0 n14_0 n15_0 100
C14_1 n14_1 0 1p
Rh14_1 n14_1 n14_2 100
Rv14_1 n14_1 n15_1 100
C14_2 n14_2 0 1p
Rh14_2 n14_2 n14_3 100
Rv14_2 n14_2 n15_2 100
C14_3 n14_3 0 1p
Rh14_3 n14_3 n14_4 100
Rv14_3 n14_3 n15_3 100
C14_4 n14_4 0 1p
Rh14_4 n14_4 n14_5 100
Rv14_4 n14_4 n15_4 100
C14_5 n14_5 0 1p
Rh14_5 n14_5 n14_6 100
Rv14_5 n14_5 n15_5 100
C14_6 n14_6 0 1p
Rh14_6 n14_6 n14_7 100
Rv14_6 n14_6 n15_6 100
C14_7 n14_7 0 1p
Rh14_7 n14_7 n14_8 100
Rv14_7 n14_7 n15_7 100
C14_8 n14_8 0 1p
Rh14_8 n14_8 n14_9 100
Rv14_8 n14_8 n15_8 100
C14_9 n14_9 0 1p
Rh14_9 n14_9 n14_10 100
Rv14_9 n14_9 n15_9 100
C14_10 n14_10 0 1p
Rh14_10 n14_10 n14_11 100
Rv14_10 n14_10 n15_10 100
C14_11 n14_11 0 1p
Rh14_11 n14_11 n14_12 100
Rv14_11 n14_11 n15_11 100
C14_12 n14_12 0 1p
Rh14_12 n14_12 n14_13 100
Rv14_12 n14_12 n15_12 100
C14_13 n14_13 0 1p
Rh14_13 n14_13 n14_14 100
Rv14_13 n14_13 n15_13 100
C14_14 n14_14 0 1p
Rh14_14 n14_14 n14_15 100
Rv14_14 n14_14 n15_14 100
C14_15 n14_15 0 1p
Rv14_15 n14_15 n15_15 100
C15_0 n15_0 0 1p
Rh15_0 n15_0 n15_1 100
C15_1 n15_1 0 1p
Rh15_1 n15_1 n15_2 100
C15_2 n15_2 0 1p
Rh15_2 n15_2 n15_3 100
C15_3 n15_3 0 1p
Rh15_3 n15_3 n15_4 100
C15_4 n15_4 0 1p
Rh15_4 n15_4 n15_5 100
C15_5 n15_5 0 1p
Rh15_5 n15_5 n15_6 100
C15_6 n15_6 0 1p
Rh15_6 n15_6 n15_7 100
C15_7 n15_7 0 1p
Rh15_7 n15_7 n15_8 100
C15_8 n15_8 0 1p
Rh15_8 n15_8 n15_9 100
C15_9 n15_9 0 1p
Rh15_9 n15_9 n15_10 100
C15_10 n15_10 0 1p
Rh15_10 n15_10 n15_11 100
C15_11 n15_11 0 1p
Rh15_11 n15_11 n15_12 100
C15_12 n15_12 0 1p
Rh15_12 n15_12 n15_13 100
C15_13 n15_13 0 1p
Rh15_13 n15_13 n15_14 100
C15_14 n15_14 0 1p
Rh15_14 n15_14 n15_15 100
C15_15 n15_15 0 1p
.tran 10p 30.005n
.end
