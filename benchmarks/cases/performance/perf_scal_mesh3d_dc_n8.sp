3-D resistor mesh 8x8x8, 1k edges, 50k leak per node, corner driven, one operating point
* bench.id: perf_scal_mesh3d_dc_n8
* bench.group: performance
* bench.title: 3-D resistor mesh 8x8x8, 1k edges, 50k leak per node, corner driven, one operating point
* bench.probes: v(n4_4_4), v(n7_7_7), v(n1_0_0), v(n0_0_7), i(v1)
* bench.tol.rel: 1e-6
* bench.tol.abs: 1e-9
* bench.expect: match
* bench.oracle: dc_linear
* bench.ng.solver: both
* bench.timing: yes
* bench.size: 513
* bench.est_rss_mib: 35
* bench.tags: linear, op, mesh, mesh3d, faer_tier, memory, family:perf_scal_mesh3d_dc
* bench.note: 513 unknowns (512 node voltages plus the V1 branch), smallest member of the 3-D mesh family perf_scal_mesh3d_dc (size = unknowns); independent oracle: a scipy sparse LU of the nodal system (V1 eliminated) agrees with both tools at all 512 nodes to 7e-15 V (v(n4_4_4)=0.611772 V, v(n7_7_7)=0.520178 V, i(v1)=-7.2955 mA); measured on an idle core (median of 5, faer supernodal tier): rustspice e2e 43 ms (compile 37.5 ms, solve 3.9 ms, VmHWM 22.9 MiB) vs ngspice KLU 13.8 ms and SPARSE 38.1 ms
V1 n0_0_0 0 5
Rx0_0_0 n0_0_0 n1_0_0 1k
Ry0_0_0 n0_0_0 n0_1_0 1k
Rz0_0_0 n0_0_0 n0_0_1 1k
Rg0_0_0 n0_0_0 0 50k
Rx0_0_1 n0_0_1 n1_0_1 1k
Ry0_0_1 n0_0_1 n0_1_1 1k
Rz0_0_1 n0_0_1 n0_0_2 1k
Rg0_0_1 n0_0_1 0 50k
Rx0_0_2 n0_0_2 n1_0_2 1k
Ry0_0_2 n0_0_2 n0_1_2 1k
Rz0_0_2 n0_0_2 n0_0_3 1k
Rg0_0_2 n0_0_2 0 50k
Rx0_0_3 n0_0_3 n1_0_3 1k
Ry0_0_3 n0_0_3 n0_1_3 1k
Rz0_0_3 n0_0_3 n0_0_4 1k
Rg0_0_3 n0_0_3 0 50k
Rx0_0_4 n0_0_4 n1_0_4 1k
Ry0_0_4 n0_0_4 n0_1_4 1k
Rz0_0_4 n0_0_4 n0_0_5 1k
Rg0_0_4 n0_0_4 0 50k
Rx0_0_5 n0_0_5 n1_0_5 1k
Ry0_0_5 n0_0_5 n0_1_5 1k
Rz0_0_5 n0_0_5 n0_0_6 1k
Rg0_0_5 n0_0_5 0 50k
Rx0_0_6 n0_0_6 n1_0_6 1k
Ry0_0_6 n0_0_6 n0_1_6 1k
Rz0_0_6 n0_0_6 n0_0_7 1k
Rg0_0_6 n0_0_6 0 50k
Rx0_0_7 n0_0_7 n1_0_7 1k
Ry0_0_7 n0_0_7 n0_1_7 1k
Rg0_0_7 n0_0_7 0 50k
Rx0_1_0 n0_1_0 n1_1_0 1k
Ry0_1_0 n0_1_0 n0_2_0 1k
Rz0_1_0 n0_1_0 n0_1_1 1k
Rg0_1_0 n0_1_0 0 50k
Rx0_1_1 n0_1_1 n1_1_1 1k
Ry0_1_1 n0_1_1 n0_2_1 1k
Rz0_1_1 n0_1_1 n0_1_2 1k
Rg0_1_1 n0_1_1 0 50k
Rx0_1_2 n0_1_2 n1_1_2 1k
Ry0_1_2 n0_1_2 n0_2_2 1k
Rz0_1_2 n0_1_2 n0_1_3 1k
Rg0_1_2 n0_1_2 0 50k
Rx0_1_3 n0_1_3 n1_1_3 1k
Ry0_1_3 n0_1_3 n0_2_3 1k
Rz0_1_3 n0_1_3 n0_1_4 1k
Rg0_1_3 n0_1_3 0 50k
Rx0_1_4 n0_1_4 n1_1_4 1k
Ry0_1_4 n0_1_4 n0_2_4 1k
Rz0_1_4 n0_1_4 n0_1_5 1k
Rg0_1_4 n0_1_4 0 50k
Rx0_1_5 n0_1_5 n1_1_5 1k
Ry0_1_5 n0_1_5 n0_2_5 1k
Rz0_1_5 n0_1_5 n0_1_6 1k
Rg0_1_5 n0_1_5 0 50k
Rx0_1_6 n0_1_6 n1_1_6 1k
Ry0_1_6 n0_1_6 n0_2_6 1k
Rz0_1_6 n0_1_6 n0_1_7 1k
Rg0_1_6 n0_1_6 0 50k
Rx0_1_7 n0_1_7 n1_1_7 1k
Ry0_1_7 n0_1_7 n0_2_7 1k
Rg0_1_7 n0_1_7 0 50k
Rx0_2_0 n0_2_0 n1_2_0 1k
Ry0_2_0 n0_2_0 n0_3_0 1k
Rz0_2_0 n0_2_0 n0_2_1 1k
Rg0_2_0 n0_2_0 0 50k
Rx0_2_1 n0_2_1 n1_2_1 1k
Ry0_2_1 n0_2_1 n0_3_1 1k
Rz0_2_1 n0_2_1 n0_2_2 1k
Rg0_2_1 n0_2_1 0 50k
Rx0_2_2 n0_2_2 n1_2_2 1k
Ry0_2_2 n0_2_2 n0_3_2 1k
Rz0_2_2 n0_2_2 n0_2_3 1k
Rg0_2_2 n0_2_2 0 50k
Rx0_2_3 n0_2_3 n1_2_3 1k
Ry0_2_3 n0_2_3 n0_3_3 1k
Rz0_2_3 n0_2_3 n0_2_4 1k
Rg0_2_3 n0_2_3 0 50k
Rx0_2_4 n0_2_4 n1_2_4 1k
Ry0_2_4 n0_2_4 n0_3_4 1k
Rz0_2_4 n0_2_4 n0_2_5 1k
Rg0_2_4 n0_2_4 0 50k
Rx0_2_5 n0_2_5 n1_2_5 1k
Ry0_2_5 n0_2_5 n0_3_5 1k
Rz0_2_5 n0_2_5 n0_2_6 1k
Rg0_2_5 n0_2_5 0 50k
Rx0_2_6 n0_2_6 n1_2_6 1k
Ry0_2_6 n0_2_6 n0_3_6 1k
Rz0_2_6 n0_2_6 n0_2_7 1k
Rg0_2_6 n0_2_6 0 50k
Rx0_2_7 n0_2_7 n1_2_7 1k
Ry0_2_7 n0_2_7 n0_3_7 1k
Rg0_2_7 n0_2_7 0 50k
Rx0_3_0 n0_3_0 n1_3_0 1k
Ry0_3_0 n0_3_0 n0_4_0 1k
Rz0_3_0 n0_3_0 n0_3_1 1k
Rg0_3_0 n0_3_0 0 50k
Rx0_3_1 n0_3_1 n1_3_1 1k
Ry0_3_1 n0_3_1 n0_4_1 1k
Rz0_3_1 n0_3_1 n0_3_2 1k
Rg0_3_1 n0_3_1 0 50k
Rx0_3_2 n0_3_2 n1_3_2 1k
Ry0_3_2 n0_3_2 n0_4_2 1k
Rz0_3_2 n0_3_2 n0_3_3 1k
Rg0_3_2 n0_3_2 0 50k
Rx0_3_3 n0_3_3 n1_3_3 1k
Ry0_3_3 n0_3_3 n0_4_3 1k
Rz0_3_3 n0_3_3 n0_3_4 1k
Rg0_3_3 n0_3_3 0 50k
Rx0_3_4 n0_3_4 n1_3_4 1k
Ry0_3_4 n0_3_4 n0_4_4 1k
Rz0_3_4 n0_3_4 n0_3_5 1k
Rg0_3_4 n0_3_4 0 50k
Rx0_3_5 n0_3_5 n1_3_5 1k
Ry0_3_5 n0_3_5 n0_4_5 1k
Rz0_3_5 n0_3_5 n0_3_6 1k
Rg0_3_5 n0_3_5 0 50k
Rx0_3_6 n0_3_6 n1_3_6 1k
Ry0_3_6 n0_3_6 n0_4_6 1k
Rz0_3_6 n0_3_6 n0_3_7 1k
Rg0_3_6 n0_3_6 0 50k
Rx0_3_7 n0_3_7 n1_3_7 1k
Ry0_3_7 n0_3_7 n0_4_7 1k
Rg0_3_7 n0_3_7 0 50k
Rx0_4_0 n0_4_0 n1_4_0 1k
Ry0_4_0 n0_4_0 n0_5_0 1k
Rz0_4_0 n0_4_0 n0_4_1 1k
Rg0_4_0 n0_4_0 0 50k
Rx0_4_1 n0_4_1 n1_4_1 1k
Ry0_4_1 n0_4_1 n0_5_1 1k
Rz0_4_1 n0_4_1 n0_4_2 1k
Rg0_4_1 n0_4_1 0 50k
Rx0_4_2 n0_4_2 n1_4_2 1k
Ry0_4_2 n0_4_2 n0_5_2 1k
Rz0_4_2 n0_4_2 n0_4_3 1k
Rg0_4_2 n0_4_2 0 50k
Rx0_4_3 n0_4_3 n1_4_3 1k
Ry0_4_3 n0_4_3 n0_5_3 1k
Rz0_4_3 n0_4_3 n0_4_4 1k
Rg0_4_3 n0_4_3 0 50k
Rx0_4_4 n0_4_4 n1_4_4 1k
Ry0_4_4 n0_4_4 n0_5_4 1k
Rz0_4_4 n0_4_4 n0_4_5 1k
Rg0_4_4 n0_4_4 0 50k
Rx0_4_5 n0_4_5 n1_4_5 1k
Ry0_4_5 n0_4_5 n0_5_5 1k
Rz0_4_5 n0_4_5 n0_4_6 1k
Rg0_4_5 n0_4_5 0 50k
Rx0_4_6 n0_4_6 n1_4_6 1k
Ry0_4_6 n0_4_6 n0_5_6 1k
Rz0_4_6 n0_4_6 n0_4_7 1k
Rg0_4_6 n0_4_6 0 50k
Rx0_4_7 n0_4_7 n1_4_7 1k
Ry0_4_7 n0_4_7 n0_5_7 1k
Rg0_4_7 n0_4_7 0 50k
Rx0_5_0 n0_5_0 n1_5_0 1k
Ry0_5_0 n0_5_0 n0_6_0 1k
Rz0_5_0 n0_5_0 n0_5_1 1k
Rg0_5_0 n0_5_0 0 50k
Rx0_5_1 n0_5_1 n1_5_1 1k
Ry0_5_1 n0_5_1 n0_6_1 1k
Rz0_5_1 n0_5_1 n0_5_2 1k
Rg0_5_1 n0_5_1 0 50k
Rx0_5_2 n0_5_2 n1_5_2 1k
Ry0_5_2 n0_5_2 n0_6_2 1k
Rz0_5_2 n0_5_2 n0_5_3 1k
Rg0_5_2 n0_5_2 0 50k
Rx0_5_3 n0_5_3 n1_5_3 1k
Ry0_5_3 n0_5_3 n0_6_3 1k
Rz0_5_3 n0_5_3 n0_5_4 1k
Rg0_5_3 n0_5_3 0 50k
Rx0_5_4 n0_5_4 n1_5_4 1k
Ry0_5_4 n0_5_4 n0_6_4 1k
Rz0_5_4 n0_5_4 n0_5_5 1k
Rg0_5_4 n0_5_4 0 50k
Rx0_5_5 n0_5_5 n1_5_5 1k
Ry0_5_5 n0_5_5 n0_6_5 1k
Rz0_5_5 n0_5_5 n0_5_6 1k
Rg0_5_5 n0_5_5 0 50k
Rx0_5_6 n0_5_6 n1_5_6 1k
Ry0_5_6 n0_5_6 n0_6_6 1k
Rz0_5_6 n0_5_6 n0_5_7 1k
Rg0_5_6 n0_5_6 0 50k
Rx0_5_7 n0_5_7 n1_5_7 1k
Ry0_5_7 n0_5_7 n0_6_7 1k
Rg0_5_7 n0_5_7 0 50k
Rx0_6_0 n0_6_0 n1_6_0 1k
Ry0_6_0 n0_6_0 n0_7_0 1k
Rz0_6_0 n0_6_0 n0_6_1 1k
Rg0_6_0 n0_6_0 0 50k
Rx0_6_1 n0_6_1 n1_6_1 1k
Ry0_6_1 n0_6_1 n0_7_1 1k
Rz0_6_1 n0_6_1 n0_6_2 1k
Rg0_6_1 n0_6_1 0 50k
Rx0_6_2 n0_6_2 n1_6_2 1k
Ry0_6_2 n0_6_2 n0_7_2 1k
Rz0_6_2 n0_6_2 n0_6_3 1k
Rg0_6_2 n0_6_2 0 50k
Rx0_6_3 n0_6_3 n1_6_3 1k
Ry0_6_3 n0_6_3 n0_7_3 1k
Rz0_6_3 n0_6_3 n0_6_4 1k
Rg0_6_3 n0_6_3 0 50k
Rx0_6_4 n0_6_4 n1_6_4 1k
Ry0_6_4 n0_6_4 n0_7_4 1k
Rz0_6_4 n0_6_4 n0_6_5 1k
Rg0_6_4 n0_6_4 0 50k
Rx0_6_5 n0_6_5 n1_6_5 1k
Ry0_6_5 n0_6_5 n0_7_5 1k
Rz0_6_5 n0_6_5 n0_6_6 1k
Rg0_6_5 n0_6_5 0 50k
Rx0_6_6 n0_6_6 n1_6_6 1k
Ry0_6_6 n0_6_6 n0_7_6 1k
Rz0_6_6 n0_6_6 n0_6_7 1k
Rg0_6_6 n0_6_6 0 50k
Rx0_6_7 n0_6_7 n1_6_7 1k
Ry0_6_7 n0_6_7 n0_7_7 1k
Rg0_6_7 n0_6_7 0 50k
Rx0_7_0 n0_7_0 n1_7_0 1k
Rz0_7_0 n0_7_0 n0_7_1 1k
Rg0_7_0 n0_7_0 0 50k
Rx0_7_1 n0_7_1 n1_7_1 1k
Rz0_7_1 n0_7_1 n0_7_2 1k
Rg0_7_1 n0_7_1 0 50k
Rx0_7_2 n0_7_2 n1_7_2 1k
Rz0_7_2 n0_7_2 n0_7_3 1k
Rg0_7_2 n0_7_2 0 50k
Rx0_7_3 n0_7_3 n1_7_3 1k
Rz0_7_3 n0_7_3 n0_7_4 1k
Rg0_7_3 n0_7_3 0 50k
Rx0_7_4 n0_7_4 n1_7_4 1k
Rz0_7_4 n0_7_4 n0_7_5 1k
Rg0_7_4 n0_7_4 0 50k
Rx0_7_5 n0_7_5 n1_7_5 1k
Rz0_7_5 n0_7_5 n0_7_6 1k
Rg0_7_5 n0_7_5 0 50k
Rx0_7_6 n0_7_6 n1_7_6 1k
Rz0_7_6 n0_7_6 n0_7_7 1k
Rg0_7_6 n0_7_6 0 50k
Rx0_7_7 n0_7_7 n1_7_7 1k
Rg0_7_7 n0_7_7 0 50k
Rx1_0_0 n1_0_0 n2_0_0 1k
Ry1_0_0 n1_0_0 n1_1_0 1k
Rz1_0_0 n1_0_0 n1_0_1 1k
Rg1_0_0 n1_0_0 0 50k
Rx1_0_1 n1_0_1 n2_0_1 1k
Ry1_0_1 n1_0_1 n1_1_1 1k
Rz1_0_1 n1_0_1 n1_0_2 1k
Rg1_0_1 n1_0_1 0 50k
Rx1_0_2 n1_0_2 n2_0_2 1k
Ry1_0_2 n1_0_2 n1_1_2 1k
Rz1_0_2 n1_0_2 n1_0_3 1k
Rg1_0_2 n1_0_2 0 50k
Rx1_0_3 n1_0_3 n2_0_3 1k
Ry1_0_3 n1_0_3 n1_1_3 1k
Rz1_0_3 n1_0_3 n1_0_4 1k
Rg1_0_3 n1_0_3 0 50k
Rx1_0_4 n1_0_4 n2_0_4 1k
Ry1_0_4 n1_0_4 n1_1_4 1k
Rz1_0_4 n1_0_4 n1_0_5 1k
Rg1_0_4 n1_0_4 0 50k
Rx1_0_5 n1_0_5 n2_0_5 1k
Ry1_0_5 n1_0_5 n1_1_5 1k
Rz1_0_5 n1_0_5 n1_0_6 1k
Rg1_0_5 n1_0_5 0 50k
Rx1_0_6 n1_0_6 n2_0_6 1k
Ry1_0_6 n1_0_6 n1_1_6 1k
Rz1_0_6 n1_0_6 n1_0_7 1k
Rg1_0_6 n1_0_6 0 50k
Rx1_0_7 n1_0_7 n2_0_7 1k
Ry1_0_7 n1_0_7 n1_1_7 1k
Rg1_0_7 n1_0_7 0 50k
Rx1_1_0 n1_1_0 n2_1_0 1k
Ry1_1_0 n1_1_0 n1_2_0 1k
Rz1_1_0 n1_1_0 n1_1_1 1k
Rg1_1_0 n1_1_0 0 50k
Rx1_1_1 n1_1_1 n2_1_1 1k
Ry1_1_1 n1_1_1 n1_2_1 1k
Rz1_1_1 n1_1_1 n1_1_2 1k
Rg1_1_1 n1_1_1 0 50k
Rx1_1_2 n1_1_2 n2_1_2 1k
Ry1_1_2 n1_1_2 n1_2_2 1k
Rz1_1_2 n1_1_2 n1_1_3 1k
Rg1_1_2 n1_1_2 0 50k
Rx1_1_3 n1_1_3 n2_1_3 1k
Ry1_1_3 n1_1_3 n1_2_3 1k
Rz1_1_3 n1_1_3 n1_1_4 1k
Rg1_1_3 n1_1_3 0 50k
Rx1_1_4 n1_1_4 n2_1_4 1k
Ry1_1_4 n1_1_4 n1_2_4 1k
Rz1_1_4 n1_1_4 n1_1_5 1k
Rg1_1_4 n1_1_4 0 50k
Rx1_1_5 n1_1_5 n2_1_5 1k
Ry1_1_5 n1_1_5 n1_2_5 1k
Rz1_1_5 n1_1_5 n1_1_6 1k
Rg1_1_5 n1_1_5 0 50k
Rx1_1_6 n1_1_6 n2_1_6 1k
Ry1_1_6 n1_1_6 n1_2_6 1k
Rz1_1_6 n1_1_6 n1_1_7 1k
Rg1_1_6 n1_1_6 0 50k
Rx1_1_7 n1_1_7 n2_1_7 1k
Ry1_1_7 n1_1_7 n1_2_7 1k
Rg1_1_7 n1_1_7 0 50k
Rx1_2_0 n1_2_0 n2_2_0 1k
Ry1_2_0 n1_2_0 n1_3_0 1k
Rz1_2_0 n1_2_0 n1_2_1 1k
Rg1_2_0 n1_2_0 0 50k
Rx1_2_1 n1_2_1 n2_2_1 1k
Ry1_2_1 n1_2_1 n1_3_1 1k
Rz1_2_1 n1_2_1 n1_2_2 1k
Rg1_2_1 n1_2_1 0 50k
Rx1_2_2 n1_2_2 n2_2_2 1k
Ry1_2_2 n1_2_2 n1_3_2 1k
Rz1_2_2 n1_2_2 n1_2_3 1k
Rg1_2_2 n1_2_2 0 50k
Rx1_2_3 n1_2_3 n2_2_3 1k
Ry1_2_3 n1_2_3 n1_3_3 1k
Rz1_2_3 n1_2_3 n1_2_4 1k
Rg1_2_3 n1_2_3 0 50k
Rx1_2_4 n1_2_4 n2_2_4 1k
Ry1_2_4 n1_2_4 n1_3_4 1k
Rz1_2_4 n1_2_4 n1_2_5 1k
Rg1_2_4 n1_2_4 0 50k
Rx1_2_5 n1_2_5 n2_2_5 1k
Ry1_2_5 n1_2_5 n1_3_5 1k
Rz1_2_5 n1_2_5 n1_2_6 1k
Rg1_2_5 n1_2_5 0 50k
Rx1_2_6 n1_2_6 n2_2_6 1k
Ry1_2_6 n1_2_6 n1_3_6 1k
Rz1_2_6 n1_2_6 n1_2_7 1k
Rg1_2_6 n1_2_6 0 50k
Rx1_2_7 n1_2_7 n2_2_7 1k
Ry1_2_7 n1_2_7 n1_3_7 1k
Rg1_2_7 n1_2_7 0 50k
Rx1_3_0 n1_3_0 n2_3_0 1k
Ry1_3_0 n1_3_0 n1_4_0 1k
Rz1_3_0 n1_3_0 n1_3_1 1k
Rg1_3_0 n1_3_0 0 50k
Rx1_3_1 n1_3_1 n2_3_1 1k
Ry1_3_1 n1_3_1 n1_4_1 1k
Rz1_3_1 n1_3_1 n1_3_2 1k
Rg1_3_1 n1_3_1 0 50k
Rx1_3_2 n1_3_2 n2_3_2 1k
Ry1_3_2 n1_3_2 n1_4_2 1k
Rz1_3_2 n1_3_2 n1_3_3 1k
Rg1_3_2 n1_3_2 0 50k
Rx1_3_3 n1_3_3 n2_3_3 1k
Ry1_3_3 n1_3_3 n1_4_3 1k
Rz1_3_3 n1_3_3 n1_3_4 1k
Rg1_3_3 n1_3_3 0 50k
Rx1_3_4 n1_3_4 n2_3_4 1k
Ry1_3_4 n1_3_4 n1_4_4 1k
Rz1_3_4 n1_3_4 n1_3_5 1k
Rg1_3_4 n1_3_4 0 50k
Rx1_3_5 n1_3_5 n2_3_5 1k
Ry1_3_5 n1_3_5 n1_4_5 1k
Rz1_3_5 n1_3_5 n1_3_6 1k
Rg1_3_5 n1_3_5 0 50k
Rx1_3_6 n1_3_6 n2_3_6 1k
Ry1_3_6 n1_3_6 n1_4_6 1k
Rz1_3_6 n1_3_6 n1_3_7 1k
Rg1_3_6 n1_3_6 0 50k
Rx1_3_7 n1_3_7 n2_3_7 1k
Ry1_3_7 n1_3_7 n1_4_7 1k
Rg1_3_7 n1_3_7 0 50k
Rx1_4_0 n1_4_0 n2_4_0 1k
Ry1_4_0 n1_4_0 n1_5_0 1k
Rz1_4_0 n1_4_0 n1_4_1 1k
Rg1_4_0 n1_4_0 0 50k
Rx1_4_1 n1_4_1 n2_4_1 1k
Ry1_4_1 n1_4_1 n1_5_1 1k
Rz1_4_1 n1_4_1 n1_4_2 1k
Rg1_4_1 n1_4_1 0 50k
Rx1_4_2 n1_4_2 n2_4_2 1k
Ry1_4_2 n1_4_2 n1_5_2 1k
Rz1_4_2 n1_4_2 n1_4_3 1k
Rg1_4_2 n1_4_2 0 50k
Rx1_4_3 n1_4_3 n2_4_3 1k
Ry1_4_3 n1_4_3 n1_5_3 1k
Rz1_4_3 n1_4_3 n1_4_4 1k
Rg1_4_3 n1_4_3 0 50k
Rx1_4_4 n1_4_4 n2_4_4 1k
Ry1_4_4 n1_4_4 n1_5_4 1k
Rz1_4_4 n1_4_4 n1_4_5 1k
Rg1_4_4 n1_4_4 0 50k
Rx1_4_5 n1_4_5 n2_4_5 1k
Ry1_4_5 n1_4_5 n1_5_5 1k
Rz1_4_5 n1_4_5 n1_4_6 1k
Rg1_4_5 n1_4_5 0 50k
Rx1_4_6 n1_4_6 n2_4_6 1k
Ry1_4_6 n1_4_6 n1_5_6 1k
Rz1_4_6 n1_4_6 n1_4_7 1k
Rg1_4_6 n1_4_6 0 50k
Rx1_4_7 n1_4_7 n2_4_7 1k
Ry1_4_7 n1_4_7 n1_5_7 1k
Rg1_4_7 n1_4_7 0 50k
Rx1_5_0 n1_5_0 n2_5_0 1k
Ry1_5_0 n1_5_0 n1_6_0 1k
Rz1_5_0 n1_5_0 n1_5_1 1k
Rg1_5_0 n1_5_0 0 50k
Rx1_5_1 n1_5_1 n2_5_1 1k
Ry1_5_1 n1_5_1 n1_6_1 1k
Rz1_5_1 n1_5_1 n1_5_2 1k
Rg1_5_1 n1_5_1 0 50k
Rx1_5_2 n1_5_2 n2_5_2 1k
Ry1_5_2 n1_5_2 n1_6_2 1k
Rz1_5_2 n1_5_2 n1_5_3 1k
Rg1_5_2 n1_5_2 0 50k
Rx1_5_3 n1_5_3 n2_5_3 1k
Ry1_5_3 n1_5_3 n1_6_3 1k
Rz1_5_3 n1_5_3 n1_5_4 1k
Rg1_5_3 n1_5_3 0 50k
Rx1_5_4 n1_5_4 n2_5_4 1k
Ry1_5_4 n1_5_4 n1_6_4 1k
Rz1_5_4 n1_5_4 n1_5_5 1k
Rg1_5_4 n1_5_4 0 50k
Rx1_5_5 n1_5_5 n2_5_5 1k
Ry1_5_5 n1_5_5 n1_6_5 1k
Rz1_5_5 n1_5_5 n1_5_6 1k
Rg1_5_5 n1_5_5 0 50k
Rx1_5_6 n1_5_6 n2_5_6 1k
Ry1_5_6 n1_5_6 n1_6_6 1k
Rz1_5_6 n1_5_6 n1_5_7 1k
Rg1_5_6 n1_5_6 0 50k
Rx1_5_7 n1_5_7 n2_5_7 1k
Ry1_5_7 n1_5_7 n1_6_7 1k
Rg1_5_7 n1_5_7 0 50k
Rx1_6_0 n1_6_0 n2_6_0 1k
Ry1_6_0 n1_6_0 n1_7_0 1k
Rz1_6_0 n1_6_0 n1_6_1 1k
Rg1_6_0 n1_6_0 0 50k
Rx1_6_1 n1_6_1 n2_6_1 1k
Ry1_6_1 n1_6_1 n1_7_1 1k
Rz1_6_1 n1_6_1 n1_6_2 1k
Rg1_6_1 n1_6_1 0 50k
Rx1_6_2 n1_6_2 n2_6_2 1k
Ry1_6_2 n1_6_2 n1_7_2 1k
Rz1_6_2 n1_6_2 n1_6_3 1k
Rg1_6_2 n1_6_2 0 50k
Rx1_6_3 n1_6_3 n2_6_3 1k
Ry1_6_3 n1_6_3 n1_7_3 1k
Rz1_6_3 n1_6_3 n1_6_4 1k
Rg1_6_3 n1_6_3 0 50k
Rx1_6_4 n1_6_4 n2_6_4 1k
Ry1_6_4 n1_6_4 n1_7_4 1k
Rz1_6_4 n1_6_4 n1_6_5 1k
Rg1_6_4 n1_6_4 0 50k
Rx1_6_5 n1_6_5 n2_6_5 1k
Ry1_6_5 n1_6_5 n1_7_5 1k
Rz1_6_5 n1_6_5 n1_6_6 1k
Rg1_6_5 n1_6_5 0 50k
Rx1_6_6 n1_6_6 n2_6_6 1k
Ry1_6_6 n1_6_6 n1_7_6 1k
Rz1_6_6 n1_6_6 n1_6_7 1k
Rg1_6_6 n1_6_6 0 50k
Rx1_6_7 n1_6_7 n2_6_7 1k
Ry1_6_7 n1_6_7 n1_7_7 1k
Rg1_6_7 n1_6_7 0 50k
Rx1_7_0 n1_7_0 n2_7_0 1k
Rz1_7_0 n1_7_0 n1_7_1 1k
Rg1_7_0 n1_7_0 0 50k
Rx1_7_1 n1_7_1 n2_7_1 1k
Rz1_7_1 n1_7_1 n1_7_2 1k
Rg1_7_1 n1_7_1 0 50k
Rx1_7_2 n1_7_2 n2_7_2 1k
Rz1_7_2 n1_7_2 n1_7_3 1k
Rg1_7_2 n1_7_2 0 50k
Rx1_7_3 n1_7_3 n2_7_3 1k
Rz1_7_3 n1_7_3 n1_7_4 1k
Rg1_7_3 n1_7_3 0 50k
Rx1_7_4 n1_7_4 n2_7_4 1k
Rz1_7_4 n1_7_4 n1_7_5 1k
Rg1_7_4 n1_7_4 0 50k
Rx1_7_5 n1_7_5 n2_7_5 1k
Rz1_7_5 n1_7_5 n1_7_6 1k
Rg1_7_5 n1_7_5 0 50k
Rx1_7_6 n1_7_6 n2_7_6 1k
Rz1_7_6 n1_7_6 n1_7_7 1k
Rg1_7_6 n1_7_6 0 50k
Rx1_7_7 n1_7_7 n2_7_7 1k
Rg1_7_7 n1_7_7 0 50k
Rx2_0_0 n2_0_0 n3_0_0 1k
Ry2_0_0 n2_0_0 n2_1_0 1k
Rz2_0_0 n2_0_0 n2_0_1 1k
Rg2_0_0 n2_0_0 0 50k
Rx2_0_1 n2_0_1 n3_0_1 1k
Ry2_0_1 n2_0_1 n2_1_1 1k
Rz2_0_1 n2_0_1 n2_0_2 1k
Rg2_0_1 n2_0_1 0 50k
Rx2_0_2 n2_0_2 n3_0_2 1k
Ry2_0_2 n2_0_2 n2_1_2 1k
Rz2_0_2 n2_0_2 n2_0_3 1k
Rg2_0_2 n2_0_2 0 50k
Rx2_0_3 n2_0_3 n3_0_3 1k
Ry2_0_3 n2_0_3 n2_1_3 1k
Rz2_0_3 n2_0_3 n2_0_4 1k
Rg2_0_3 n2_0_3 0 50k
Rx2_0_4 n2_0_4 n3_0_4 1k
Ry2_0_4 n2_0_4 n2_1_4 1k
Rz2_0_4 n2_0_4 n2_0_5 1k
Rg2_0_4 n2_0_4 0 50k
Rx2_0_5 n2_0_5 n3_0_5 1k
Ry2_0_5 n2_0_5 n2_1_5 1k
Rz2_0_5 n2_0_5 n2_0_6 1k
Rg2_0_5 n2_0_5 0 50k
Rx2_0_6 n2_0_6 n3_0_6 1k
Ry2_0_6 n2_0_6 n2_1_6 1k
Rz2_0_6 n2_0_6 n2_0_7 1k
Rg2_0_6 n2_0_6 0 50k
Rx2_0_7 n2_0_7 n3_0_7 1k
Ry2_0_7 n2_0_7 n2_1_7 1k
Rg2_0_7 n2_0_7 0 50k
Rx2_1_0 n2_1_0 n3_1_0 1k
Ry2_1_0 n2_1_0 n2_2_0 1k
Rz2_1_0 n2_1_0 n2_1_1 1k
Rg2_1_0 n2_1_0 0 50k
Rx2_1_1 n2_1_1 n3_1_1 1k
Ry2_1_1 n2_1_1 n2_2_1 1k
Rz2_1_1 n2_1_1 n2_1_2 1k
Rg2_1_1 n2_1_1 0 50k
Rx2_1_2 n2_1_2 n3_1_2 1k
Ry2_1_2 n2_1_2 n2_2_2 1k
Rz2_1_2 n2_1_2 n2_1_3 1k
Rg2_1_2 n2_1_2 0 50k
Rx2_1_3 n2_1_3 n3_1_3 1k
Ry2_1_3 n2_1_3 n2_2_3 1k
Rz2_1_3 n2_1_3 n2_1_4 1k
Rg2_1_3 n2_1_3 0 50k
Rx2_1_4 n2_1_4 n3_1_4 1k
Ry2_1_4 n2_1_4 n2_2_4 1k
Rz2_1_4 n2_1_4 n2_1_5 1k
Rg2_1_4 n2_1_4 0 50k
Rx2_1_5 n2_1_5 n3_1_5 1k
Ry2_1_5 n2_1_5 n2_2_5 1k
Rz2_1_5 n2_1_5 n2_1_6 1k
Rg2_1_5 n2_1_5 0 50k
Rx2_1_6 n2_1_6 n3_1_6 1k
Ry2_1_6 n2_1_6 n2_2_6 1k
Rz2_1_6 n2_1_6 n2_1_7 1k
Rg2_1_6 n2_1_6 0 50k
Rx2_1_7 n2_1_7 n3_1_7 1k
Ry2_1_7 n2_1_7 n2_2_7 1k
Rg2_1_7 n2_1_7 0 50k
Rx2_2_0 n2_2_0 n3_2_0 1k
Ry2_2_0 n2_2_0 n2_3_0 1k
Rz2_2_0 n2_2_0 n2_2_1 1k
Rg2_2_0 n2_2_0 0 50k
Rx2_2_1 n2_2_1 n3_2_1 1k
Ry2_2_1 n2_2_1 n2_3_1 1k
Rz2_2_1 n2_2_1 n2_2_2 1k
Rg2_2_1 n2_2_1 0 50k
Rx2_2_2 n2_2_2 n3_2_2 1k
Ry2_2_2 n2_2_2 n2_3_2 1k
Rz2_2_2 n2_2_2 n2_2_3 1k
Rg2_2_2 n2_2_2 0 50k
Rx2_2_3 n2_2_3 n3_2_3 1k
Ry2_2_3 n2_2_3 n2_3_3 1k
Rz2_2_3 n2_2_3 n2_2_4 1k
Rg2_2_3 n2_2_3 0 50k
Rx2_2_4 n2_2_4 n3_2_4 1k
Ry2_2_4 n2_2_4 n2_3_4 1k
Rz2_2_4 n2_2_4 n2_2_5 1k
Rg2_2_4 n2_2_4 0 50k
Rx2_2_5 n2_2_5 n3_2_5 1k
Ry2_2_5 n2_2_5 n2_3_5 1k
Rz2_2_5 n2_2_5 n2_2_6 1k
Rg2_2_5 n2_2_5 0 50k
Rx2_2_6 n2_2_6 n3_2_6 1k
Ry2_2_6 n2_2_6 n2_3_6 1k
Rz2_2_6 n2_2_6 n2_2_7 1k
Rg2_2_6 n2_2_6 0 50k
Rx2_2_7 n2_2_7 n3_2_7 1k
Ry2_2_7 n2_2_7 n2_3_7 1k
Rg2_2_7 n2_2_7 0 50k
Rx2_3_0 n2_3_0 n3_3_0 1k
Ry2_3_0 n2_3_0 n2_4_0 1k
Rz2_3_0 n2_3_0 n2_3_1 1k
Rg2_3_0 n2_3_0 0 50k
Rx2_3_1 n2_3_1 n3_3_1 1k
Ry2_3_1 n2_3_1 n2_4_1 1k
Rz2_3_1 n2_3_1 n2_3_2 1k
Rg2_3_1 n2_3_1 0 50k
Rx2_3_2 n2_3_2 n3_3_2 1k
Ry2_3_2 n2_3_2 n2_4_2 1k
Rz2_3_2 n2_3_2 n2_3_3 1k
Rg2_3_2 n2_3_2 0 50k
Rx2_3_3 n2_3_3 n3_3_3 1k
Ry2_3_3 n2_3_3 n2_4_3 1k
Rz2_3_3 n2_3_3 n2_3_4 1k
Rg2_3_3 n2_3_3 0 50k
Rx2_3_4 n2_3_4 n3_3_4 1k
Ry2_3_4 n2_3_4 n2_4_4 1k
Rz2_3_4 n2_3_4 n2_3_5 1k
Rg2_3_4 n2_3_4 0 50k
Rx2_3_5 n2_3_5 n3_3_5 1k
Ry2_3_5 n2_3_5 n2_4_5 1k
Rz2_3_5 n2_3_5 n2_3_6 1k
Rg2_3_5 n2_3_5 0 50k
Rx2_3_6 n2_3_6 n3_3_6 1k
Ry2_3_6 n2_3_6 n2_4_6 1k
Rz2_3_6 n2_3_6 n2_3_7 1k
Rg2_3_6 n2_3_6 0 50k
Rx2_3_7 n2_3_7 n3_3_7 1k
Ry2_3_7 n2_3_7 n2_4_7 1k
Rg2_3_7 n2_3_7 0 50k
Rx2_4_0 n2_4_0 n3_4_0 1k
Ry2_4_0 n2_4_0 n2_5_0 1k
Rz2_4_0 n2_4_0 n2_4_1 1k
Rg2_4_0 n2_4_0 0 50k
Rx2_4_1 n2_4_1 n3_4_1 1k
Ry2_4_1 n2_4_1 n2_5_1 1k
Rz2_4_1 n2_4_1 n2_4_2 1k
Rg2_4_1 n2_4_1 0 50k
Rx2_4_2 n2_4_2 n3_4_2 1k
Ry2_4_2 n2_4_2 n2_5_2 1k
Rz2_4_2 n2_4_2 n2_4_3 1k
Rg2_4_2 n2_4_2 0 50k
Rx2_4_3 n2_4_3 n3_4_3 1k
Ry2_4_3 n2_4_3 n2_5_3 1k
Rz2_4_3 n2_4_3 n2_4_4 1k
Rg2_4_3 n2_4_3 0 50k
Rx2_4_4 n2_4_4 n3_4_4 1k
Ry2_4_4 n2_4_4 n2_5_4 1k
Rz2_4_4 n2_4_4 n2_4_5 1k
Rg2_4_4 n2_4_4 0 50k
Rx2_4_5 n2_4_5 n3_4_5 1k
Ry2_4_5 n2_4_5 n2_5_5 1k
Rz2_4_5 n2_4_5 n2_4_6 1k
Rg2_4_5 n2_4_5 0 50k
Rx2_4_6 n2_4_6 n3_4_6 1k
Ry2_4_6 n2_4_6 n2_5_6 1k
Rz2_4_6 n2_4_6 n2_4_7 1k
Rg2_4_6 n2_4_6 0 50k
Rx2_4_7 n2_4_7 n3_4_7 1k
Ry2_4_7 n2_4_7 n2_5_7 1k
Rg2_4_7 n2_4_7 0 50k
Rx2_5_0 n2_5_0 n3_5_0 1k
Ry2_5_0 n2_5_0 n2_6_0 1k
Rz2_5_0 n2_5_0 n2_5_1 1k
Rg2_5_0 n2_5_0 0 50k
Rx2_5_1 n2_5_1 n3_5_1 1k
Ry2_5_1 n2_5_1 n2_6_1 1k
Rz2_5_1 n2_5_1 n2_5_2 1k
Rg2_5_1 n2_5_1 0 50k
Rx2_5_2 n2_5_2 n3_5_2 1k
Ry2_5_2 n2_5_2 n2_6_2 1k
Rz2_5_2 n2_5_2 n2_5_3 1k
Rg2_5_2 n2_5_2 0 50k
Rx2_5_3 n2_5_3 n3_5_3 1k
Ry2_5_3 n2_5_3 n2_6_3 1k
Rz2_5_3 n2_5_3 n2_5_4 1k
Rg2_5_3 n2_5_3 0 50k
Rx2_5_4 n2_5_4 n3_5_4 1k
Ry2_5_4 n2_5_4 n2_6_4 1k
Rz2_5_4 n2_5_4 n2_5_5 1k
Rg2_5_4 n2_5_4 0 50k
Rx2_5_5 n2_5_5 n3_5_5 1k
Ry2_5_5 n2_5_5 n2_6_5 1k
Rz2_5_5 n2_5_5 n2_5_6 1k
Rg2_5_5 n2_5_5 0 50k
Rx2_5_6 n2_5_6 n3_5_6 1k
Ry2_5_6 n2_5_6 n2_6_6 1k
Rz2_5_6 n2_5_6 n2_5_7 1k
Rg2_5_6 n2_5_6 0 50k
Rx2_5_7 n2_5_7 n3_5_7 1k
Ry2_5_7 n2_5_7 n2_6_7 1k
Rg2_5_7 n2_5_7 0 50k
Rx2_6_0 n2_6_0 n3_6_0 1k
Ry2_6_0 n2_6_0 n2_7_0 1k
Rz2_6_0 n2_6_0 n2_6_1 1k
Rg2_6_0 n2_6_0 0 50k
Rx2_6_1 n2_6_1 n3_6_1 1k
Ry2_6_1 n2_6_1 n2_7_1 1k
Rz2_6_1 n2_6_1 n2_6_2 1k
Rg2_6_1 n2_6_1 0 50k
Rx2_6_2 n2_6_2 n3_6_2 1k
Ry2_6_2 n2_6_2 n2_7_2 1k
Rz2_6_2 n2_6_2 n2_6_3 1k
Rg2_6_2 n2_6_2 0 50k
Rx2_6_3 n2_6_3 n3_6_3 1k
Ry2_6_3 n2_6_3 n2_7_3 1k
Rz2_6_3 n2_6_3 n2_6_4 1k
Rg2_6_3 n2_6_3 0 50k
Rx2_6_4 n2_6_4 n3_6_4 1k
Ry2_6_4 n2_6_4 n2_7_4 1k
Rz2_6_4 n2_6_4 n2_6_5 1k
Rg2_6_4 n2_6_4 0 50k
Rx2_6_5 n2_6_5 n3_6_5 1k
Ry2_6_5 n2_6_5 n2_7_5 1k
Rz2_6_5 n2_6_5 n2_6_6 1k
Rg2_6_5 n2_6_5 0 50k
Rx2_6_6 n2_6_6 n3_6_6 1k
Ry2_6_6 n2_6_6 n2_7_6 1k
Rz2_6_6 n2_6_6 n2_6_7 1k
Rg2_6_6 n2_6_6 0 50k
Rx2_6_7 n2_6_7 n3_6_7 1k
Ry2_6_7 n2_6_7 n2_7_7 1k
Rg2_6_7 n2_6_7 0 50k
Rx2_7_0 n2_7_0 n3_7_0 1k
Rz2_7_0 n2_7_0 n2_7_1 1k
Rg2_7_0 n2_7_0 0 50k
Rx2_7_1 n2_7_1 n3_7_1 1k
Rz2_7_1 n2_7_1 n2_7_2 1k
Rg2_7_1 n2_7_1 0 50k
Rx2_7_2 n2_7_2 n3_7_2 1k
Rz2_7_2 n2_7_2 n2_7_3 1k
Rg2_7_2 n2_7_2 0 50k
Rx2_7_3 n2_7_3 n3_7_3 1k
Rz2_7_3 n2_7_3 n2_7_4 1k
Rg2_7_3 n2_7_3 0 50k
Rx2_7_4 n2_7_4 n3_7_4 1k
Rz2_7_4 n2_7_4 n2_7_5 1k
Rg2_7_4 n2_7_4 0 50k
Rx2_7_5 n2_7_5 n3_7_5 1k
Rz2_7_5 n2_7_5 n2_7_6 1k
Rg2_7_5 n2_7_5 0 50k
Rx2_7_6 n2_7_6 n3_7_6 1k
Rz2_7_6 n2_7_6 n2_7_7 1k
Rg2_7_6 n2_7_6 0 50k
Rx2_7_7 n2_7_7 n3_7_7 1k
Rg2_7_7 n2_7_7 0 50k
Rx3_0_0 n3_0_0 n4_0_0 1k
Ry3_0_0 n3_0_0 n3_1_0 1k
Rz3_0_0 n3_0_0 n3_0_1 1k
Rg3_0_0 n3_0_0 0 50k
Rx3_0_1 n3_0_1 n4_0_1 1k
Ry3_0_1 n3_0_1 n3_1_1 1k
Rz3_0_1 n3_0_1 n3_0_2 1k
Rg3_0_1 n3_0_1 0 50k
Rx3_0_2 n3_0_2 n4_0_2 1k
Ry3_0_2 n3_0_2 n3_1_2 1k
Rz3_0_2 n3_0_2 n3_0_3 1k
Rg3_0_2 n3_0_2 0 50k
Rx3_0_3 n3_0_3 n4_0_3 1k
Ry3_0_3 n3_0_3 n3_1_3 1k
Rz3_0_3 n3_0_3 n3_0_4 1k
Rg3_0_3 n3_0_3 0 50k
Rx3_0_4 n3_0_4 n4_0_4 1k
Ry3_0_4 n3_0_4 n3_1_4 1k
Rz3_0_4 n3_0_4 n3_0_5 1k
Rg3_0_4 n3_0_4 0 50k
Rx3_0_5 n3_0_5 n4_0_5 1k
Ry3_0_5 n3_0_5 n3_1_5 1k
Rz3_0_5 n3_0_5 n3_0_6 1k
Rg3_0_5 n3_0_5 0 50k
Rx3_0_6 n3_0_6 n4_0_6 1k
Ry3_0_6 n3_0_6 n3_1_6 1k
Rz3_0_6 n3_0_6 n3_0_7 1k
Rg3_0_6 n3_0_6 0 50k
Rx3_0_7 n3_0_7 n4_0_7 1k
Ry3_0_7 n3_0_7 n3_1_7 1k
Rg3_0_7 n3_0_7 0 50k
Rx3_1_0 n3_1_0 n4_1_0 1k
Ry3_1_0 n3_1_0 n3_2_0 1k
Rz3_1_0 n3_1_0 n3_1_1 1k
Rg3_1_0 n3_1_0 0 50k
Rx3_1_1 n3_1_1 n4_1_1 1k
Ry3_1_1 n3_1_1 n3_2_1 1k
Rz3_1_1 n3_1_1 n3_1_2 1k
Rg3_1_1 n3_1_1 0 50k
Rx3_1_2 n3_1_2 n4_1_2 1k
Ry3_1_2 n3_1_2 n3_2_2 1k
Rz3_1_2 n3_1_2 n3_1_3 1k
Rg3_1_2 n3_1_2 0 50k
Rx3_1_3 n3_1_3 n4_1_3 1k
Ry3_1_3 n3_1_3 n3_2_3 1k
Rz3_1_3 n3_1_3 n3_1_4 1k
Rg3_1_3 n3_1_3 0 50k
Rx3_1_4 n3_1_4 n4_1_4 1k
Ry3_1_4 n3_1_4 n3_2_4 1k
Rz3_1_4 n3_1_4 n3_1_5 1k
Rg3_1_4 n3_1_4 0 50k
Rx3_1_5 n3_1_5 n4_1_5 1k
Ry3_1_5 n3_1_5 n3_2_5 1k
Rz3_1_5 n3_1_5 n3_1_6 1k
Rg3_1_5 n3_1_5 0 50k
Rx3_1_6 n3_1_6 n4_1_6 1k
Ry3_1_6 n3_1_6 n3_2_6 1k
Rz3_1_6 n3_1_6 n3_1_7 1k
Rg3_1_6 n3_1_6 0 50k
Rx3_1_7 n3_1_7 n4_1_7 1k
Ry3_1_7 n3_1_7 n3_2_7 1k
Rg3_1_7 n3_1_7 0 50k
Rx3_2_0 n3_2_0 n4_2_0 1k
Ry3_2_0 n3_2_0 n3_3_0 1k
Rz3_2_0 n3_2_0 n3_2_1 1k
Rg3_2_0 n3_2_0 0 50k
Rx3_2_1 n3_2_1 n4_2_1 1k
Ry3_2_1 n3_2_1 n3_3_1 1k
Rz3_2_1 n3_2_1 n3_2_2 1k
Rg3_2_1 n3_2_1 0 50k
Rx3_2_2 n3_2_2 n4_2_2 1k
Ry3_2_2 n3_2_2 n3_3_2 1k
Rz3_2_2 n3_2_2 n3_2_3 1k
Rg3_2_2 n3_2_2 0 50k
Rx3_2_3 n3_2_3 n4_2_3 1k
Ry3_2_3 n3_2_3 n3_3_3 1k
Rz3_2_3 n3_2_3 n3_2_4 1k
Rg3_2_3 n3_2_3 0 50k
Rx3_2_4 n3_2_4 n4_2_4 1k
Ry3_2_4 n3_2_4 n3_3_4 1k
Rz3_2_4 n3_2_4 n3_2_5 1k
Rg3_2_4 n3_2_4 0 50k
Rx3_2_5 n3_2_5 n4_2_5 1k
Ry3_2_5 n3_2_5 n3_3_5 1k
Rz3_2_5 n3_2_5 n3_2_6 1k
Rg3_2_5 n3_2_5 0 50k
Rx3_2_6 n3_2_6 n4_2_6 1k
Ry3_2_6 n3_2_6 n3_3_6 1k
Rz3_2_6 n3_2_6 n3_2_7 1k
Rg3_2_6 n3_2_6 0 50k
Rx3_2_7 n3_2_7 n4_2_7 1k
Ry3_2_7 n3_2_7 n3_3_7 1k
Rg3_2_7 n3_2_7 0 50k
Rx3_3_0 n3_3_0 n4_3_0 1k
Ry3_3_0 n3_3_0 n3_4_0 1k
Rz3_3_0 n3_3_0 n3_3_1 1k
Rg3_3_0 n3_3_0 0 50k
Rx3_3_1 n3_3_1 n4_3_1 1k
Ry3_3_1 n3_3_1 n3_4_1 1k
Rz3_3_1 n3_3_1 n3_3_2 1k
Rg3_3_1 n3_3_1 0 50k
Rx3_3_2 n3_3_2 n4_3_2 1k
Ry3_3_2 n3_3_2 n3_4_2 1k
Rz3_3_2 n3_3_2 n3_3_3 1k
Rg3_3_2 n3_3_2 0 50k
Rx3_3_3 n3_3_3 n4_3_3 1k
Ry3_3_3 n3_3_3 n3_4_3 1k
Rz3_3_3 n3_3_3 n3_3_4 1k
Rg3_3_3 n3_3_3 0 50k
Rx3_3_4 n3_3_4 n4_3_4 1k
Ry3_3_4 n3_3_4 n3_4_4 1k
Rz3_3_4 n3_3_4 n3_3_5 1k
Rg3_3_4 n3_3_4 0 50k
Rx3_3_5 n3_3_5 n4_3_5 1k
Ry3_3_5 n3_3_5 n3_4_5 1k
Rz3_3_5 n3_3_5 n3_3_6 1k
Rg3_3_5 n3_3_5 0 50k
Rx3_3_6 n3_3_6 n4_3_6 1k
Ry3_3_6 n3_3_6 n3_4_6 1k
Rz3_3_6 n3_3_6 n3_3_7 1k
Rg3_3_6 n3_3_6 0 50k
Rx3_3_7 n3_3_7 n4_3_7 1k
Ry3_3_7 n3_3_7 n3_4_7 1k
Rg3_3_7 n3_3_7 0 50k
Rx3_4_0 n3_4_0 n4_4_0 1k
Ry3_4_0 n3_4_0 n3_5_0 1k
Rz3_4_0 n3_4_0 n3_4_1 1k
Rg3_4_0 n3_4_0 0 50k
Rx3_4_1 n3_4_1 n4_4_1 1k
Ry3_4_1 n3_4_1 n3_5_1 1k
Rz3_4_1 n3_4_1 n3_4_2 1k
Rg3_4_1 n3_4_1 0 50k
Rx3_4_2 n3_4_2 n4_4_2 1k
Ry3_4_2 n3_4_2 n3_5_2 1k
Rz3_4_2 n3_4_2 n3_4_3 1k
Rg3_4_2 n3_4_2 0 50k
Rx3_4_3 n3_4_3 n4_4_3 1k
Ry3_4_3 n3_4_3 n3_5_3 1k
Rz3_4_3 n3_4_3 n3_4_4 1k
Rg3_4_3 n3_4_3 0 50k
Rx3_4_4 n3_4_4 n4_4_4 1k
Ry3_4_4 n3_4_4 n3_5_4 1k
Rz3_4_4 n3_4_4 n3_4_5 1k
Rg3_4_4 n3_4_4 0 50k
Rx3_4_5 n3_4_5 n4_4_5 1k
Ry3_4_5 n3_4_5 n3_5_5 1k
Rz3_4_5 n3_4_5 n3_4_6 1k
Rg3_4_5 n3_4_5 0 50k
Rx3_4_6 n3_4_6 n4_4_6 1k
Ry3_4_6 n3_4_6 n3_5_6 1k
Rz3_4_6 n3_4_6 n3_4_7 1k
Rg3_4_6 n3_4_6 0 50k
Rx3_4_7 n3_4_7 n4_4_7 1k
Ry3_4_7 n3_4_7 n3_5_7 1k
Rg3_4_7 n3_4_7 0 50k
Rx3_5_0 n3_5_0 n4_5_0 1k
Ry3_5_0 n3_5_0 n3_6_0 1k
Rz3_5_0 n3_5_0 n3_5_1 1k
Rg3_5_0 n3_5_0 0 50k
Rx3_5_1 n3_5_1 n4_5_1 1k
Ry3_5_1 n3_5_1 n3_6_1 1k
Rz3_5_1 n3_5_1 n3_5_2 1k
Rg3_5_1 n3_5_1 0 50k
Rx3_5_2 n3_5_2 n4_5_2 1k
Ry3_5_2 n3_5_2 n3_6_2 1k
Rz3_5_2 n3_5_2 n3_5_3 1k
Rg3_5_2 n3_5_2 0 50k
Rx3_5_3 n3_5_3 n4_5_3 1k
Ry3_5_3 n3_5_3 n3_6_3 1k
Rz3_5_3 n3_5_3 n3_5_4 1k
Rg3_5_3 n3_5_3 0 50k
Rx3_5_4 n3_5_4 n4_5_4 1k
Ry3_5_4 n3_5_4 n3_6_4 1k
Rz3_5_4 n3_5_4 n3_5_5 1k
Rg3_5_4 n3_5_4 0 50k
Rx3_5_5 n3_5_5 n4_5_5 1k
Ry3_5_5 n3_5_5 n3_6_5 1k
Rz3_5_5 n3_5_5 n3_5_6 1k
Rg3_5_5 n3_5_5 0 50k
Rx3_5_6 n3_5_6 n4_5_6 1k
Ry3_5_6 n3_5_6 n3_6_6 1k
Rz3_5_6 n3_5_6 n3_5_7 1k
Rg3_5_6 n3_5_6 0 50k
Rx3_5_7 n3_5_7 n4_5_7 1k
Ry3_5_7 n3_5_7 n3_6_7 1k
Rg3_5_7 n3_5_7 0 50k
Rx3_6_0 n3_6_0 n4_6_0 1k
Ry3_6_0 n3_6_0 n3_7_0 1k
Rz3_6_0 n3_6_0 n3_6_1 1k
Rg3_6_0 n3_6_0 0 50k
Rx3_6_1 n3_6_1 n4_6_1 1k
Ry3_6_1 n3_6_1 n3_7_1 1k
Rz3_6_1 n3_6_1 n3_6_2 1k
Rg3_6_1 n3_6_1 0 50k
Rx3_6_2 n3_6_2 n4_6_2 1k
Ry3_6_2 n3_6_2 n3_7_2 1k
Rz3_6_2 n3_6_2 n3_6_3 1k
Rg3_6_2 n3_6_2 0 50k
Rx3_6_3 n3_6_3 n4_6_3 1k
Ry3_6_3 n3_6_3 n3_7_3 1k
Rz3_6_3 n3_6_3 n3_6_4 1k
Rg3_6_3 n3_6_3 0 50k
Rx3_6_4 n3_6_4 n4_6_4 1k
Ry3_6_4 n3_6_4 n3_7_4 1k
Rz3_6_4 n3_6_4 n3_6_5 1k
Rg3_6_4 n3_6_4 0 50k
Rx3_6_5 n3_6_5 n4_6_5 1k
Ry3_6_5 n3_6_5 n3_7_5 1k
Rz3_6_5 n3_6_5 n3_6_6 1k
Rg3_6_5 n3_6_5 0 50k
Rx3_6_6 n3_6_6 n4_6_6 1k
Ry3_6_6 n3_6_6 n3_7_6 1k
Rz3_6_6 n3_6_6 n3_6_7 1k
Rg3_6_6 n3_6_6 0 50k
Rx3_6_7 n3_6_7 n4_6_7 1k
Ry3_6_7 n3_6_7 n3_7_7 1k
Rg3_6_7 n3_6_7 0 50k
Rx3_7_0 n3_7_0 n4_7_0 1k
Rz3_7_0 n3_7_0 n3_7_1 1k
Rg3_7_0 n3_7_0 0 50k
Rx3_7_1 n3_7_1 n4_7_1 1k
Rz3_7_1 n3_7_1 n3_7_2 1k
Rg3_7_1 n3_7_1 0 50k
Rx3_7_2 n3_7_2 n4_7_2 1k
Rz3_7_2 n3_7_2 n3_7_3 1k
Rg3_7_2 n3_7_2 0 50k
Rx3_7_3 n3_7_3 n4_7_3 1k
Rz3_7_3 n3_7_3 n3_7_4 1k
Rg3_7_3 n3_7_3 0 50k
Rx3_7_4 n3_7_4 n4_7_4 1k
Rz3_7_4 n3_7_4 n3_7_5 1k
Rg3_7_4 n3_7_4 0 50k
Rx3_7_5 n3_7_5 n4_7_5 1k
Rz3_7_5 n3_7_5 n3_7_6 1k
Rg3_7_5 n3_7_5 0 50k
Rx3_7_6 n3_7_6 n4_7_6 1k
Rz3_7_6 n3_7_6 n3_7_7 1k
Rg3_7_6 n3_7_6 0 50k
Rx3_7_7 n3_7_7 n4_7_7 1k
Rg3_7_7 n3_7_7 0 50k
Rx4_0_0 n4_0_0 n5_0_0 1k
Ry4_0_0 n4_0_0 n4_1_0 1k
Rz4_0_0 n4_0_0 n4_0_1 1k
Rg4_0_0 n4_0_0 0 50k
Rx4_0_1 n4_0_1 n5_0_1 1k
Ry4_0_1 n4_0_1 n4_1_1 1k
Rz4_0_1 n4_0_1 n4_0_2 1k
Rg4_0_1 n4_0_1 0 50k
Rx4_0_2 n4_0_2 n5_0_2 1k
Ry4_0_2 n4_0_2 n4_1_2 1k
Rz4_0_2 n4_0_2 n4_0_3 1k
Rg4_0_2 n4_0_2 0 50k
Rx4_0_3 n4_0_3 n5_0_3 1k
Ry4_0_3 n4_0_3 n4_1_3 1k
Rz4_0_3 n4_0_3 n4_0_4 1k
Rg4_0_3 n4_0_3 0 50k
Rx4_0_4 n4_0_4 n5_0_4 1k
Ry4_0_4 n4_0_4 n4_1_4 1k
Rz4_0_4 n4_0_4 n4_0_5 1k
Rg4_0_4 n4_0_4 0 50k
Rx4_0_5 n4_0_5 n5_0_5 1k
Ry4_0_5 n4_0_5 n4_1_5 1k
Rz4_0_5 n4_0_5 n4_0_6 1k
Rg4_0_5 n4_0_5 0 50k
Rx4_0_6 n4_0_6 n5_0_6 1k
Ry4_0_6 n4_0_6 n4_1_6 1k
Rz4_0_6 n4_0_6 n4_0_7 1k
Rg4_0_6 n4_0_6 0 50k
Rx4_0_7 n4_0_7 n5_0_7 1k
Ry4_0_7 n4_0_7 n4_1_7 1k
Rg4_0_7 n4_0_7 0 50k
Rx4_1_0 n4_1_0 n5_1_0 1k
Ry4_1_0 n4_1_0 n4_2_0 1k
Rz4_1_0 n4_1_0 n4_1_1 1k
Rg4_1_0 n4_1_0 0 50k
Rx4_1_1 n4_1_1 n5_1_1 1k
Ry4_1_1 n4_1_1 n4_2_1 1k
Rz4_1_1 n4_1_1 n4_1_2 1k
Rg4_1_1 n4_1_1 0 50k
Rx4_1_2 n4_1_2 n5_1_2 1k
Ry4_1_2 n4_1_2 n4_2_2 1k
Rz4_1_2 n4_1_2 n4_1_3 1k
Rg4_1_2 n4_1_2 0 50k
Rx4_1_3 n4_1_3 n5_1_3 1k
Ry4_1_3 n4_1_3 n4_2_3 1k
Rz4_1_3 n4_1_3 n4_1_4 1k
Rg4_1_3 n4_1_3 0 50k
Rx4_1_4 n4_1_4 n5_1_4 1k
Ry4_1_4 n4_1_4 n4_2_4 1k
Rz4_1_4 n4_1_4 n4_1_5 1k
Rg4_1_4 n4_1_4 0 50k
Rx4_1_5 n4_1_5 n5_1_5 1k
Ry4_1_5 n4_1_5 n4_2_5 1k
Rz4_1_5 n4_1_5 n4_1_6 1k
Rg4_1_5 n4_1_5 0 50k
Rx4_1_6 n4_1_6 n5_1_6 1k
Ry4_1_6 n4_1_6 n4_2_6 1k
Rz4_1_6 n4_1_6 n4_1_7 1k
Rg4_1_6 n4_1_6 0 50k
Rx4_1_7 n4_1_7 n5_1_7 1k
Ry4_1_7 n4_1_7 n4_2_7 1k
Rg4_1_7 n4_1_7 0 50k
Rx4_2_0 n4_2_0 n5_2_0 1k
Ry4_2_0 n4_2_0 n4_3_0 1k
Rz4_2_0 n4_2_0 n4_2_1 1k
Rg4_2_0 n4_2_0 0 50k
Rx4_2_1 n4_2_1 n5_2_1 1k
Ry4_2_1 n4_2_1 n4_3_1 1k
Rz4_2_1 n4_2_1 n4_2_2 1k
Rg4_2_1 n4_2_1 0 50k
Rx4_2_2 n4_2_2 n5_2_2 1k
Ry4_2_2 n4_2_2 n4_3_2 1k
Rz4_2_2 n4_2_2 n4_2_3 1k
Rg4_2_2 n4_2_2 0 50k
Rx4_2_3 n4_2_3 n5_2_3 1k
Ry4_2_3 n4_2_3 n4_3_3 1k
Rz4_2_3 n4_2_3 n4_2_4 1k
Rg4_2_3 n4_2_3 0 50k
Rx4_2_4 n4_2_4 n5_2_4 1k
Ry4_2_4 n4_2_4 n4_3_4 1k
Rz4_2_4 n4_2_4 n4_2_5 1k
Rg4_2_4 n4_2_4 0 50k
Rx4_2_5 n4_2_5 n5_2_5 1k
Ry4_2_5 n4_2_5 n4_3_5 1k
Rz4_2_5 n4_2_5 n4_2_6 1k
Rg4_2_5 n4_2_5 0 50k
Rx4_2_6 n4_2_6 n5_2_6 1k
Ry4_2_6 n4_2_6 n4_3_6 1k
Rz4_2_6 n4_2_6 n4_2_7 1k
Rg4_2_6 n4_2_6 0 50k
Rx4_2_7 n4_2_7 n5_2_7 1k
Ry4_2_7 n4_2_7 n4_3_7 1k
Rg4_2_7 n4_2_7 0 50k
Rx4_3_0 n4_3_0 n5_3_0 1k
Ry4_3_0 n4_3_0 n4_4_0 1k
Rz4_3_0 n4_3_0 n4_3_1 1k
Rg4_3_0 n4_3_0 0 50k
Rx4_3_1 n4_3_1 n5_3_1 1k
Ry4_3_1 n4_3_1 n4_4_1 1k
Rz4_3_1 n4_3_1 n4_3_2 1k
Rg4_3_1 n4_3_1 0 50k
Rx4_3_2 n4_3_2 n5_3_2 1k
Ry4_3_2 n4_3_2 n4_4_2 1k
Rz4_3_2 n4_3_2 n4_3_3 1k
Rg4_3_2 n4_3_2 0 50k
Rx4_3_3 n4_3_3 n5_3_3 1k
Ry4_3_3 n4_3_3 n4_4_3 1k
Rz4_3_3 n4_3_3 n4_3_4 1k
Rg4_3_3 n4_3_3 0 50k
Rx4_3_4 n4_3_4 n5_3_4 1k
Ry4_3_4 n4_3_4 n4_4_4 1k
Rz4_3_4 n4_3_4 n4_3_5 1k
Rg4_3_4 n4_3_4 0 50k
Rx4_3_5 n4_3_5 n5_3_5 1k
Ry4_3_5 n4_3_5 n4_4_5 1k
Rz4_3_5 n4_3_5 n4_3_6 1k
Rg4_3_5 n4_3_5 0 50k
Rx4_3_6 n4_3_6 n5_3_6 1k
Ry4_3_6 n4_3_6 n4_4_6 1k
Rz4_3_6 n4_3_6 n4_3_7 1k
Rg4_3_6 n4_3_6 0 50k
Rx4_3_7 n4_3_7 n5_3_7 1k
Ry4_3_7 n4_3_7 n4_4_7 1k
Rg4_3_7 n4_3_7 0 50k
Rx4_4_0 n4_4_0 n5_4_0 1k
Ry4_4_0 n4_4_0 n4_5_0 1k
Rz4_4_0 n4_4_0 n4_4_1 1k
Rg4_4_0 n4_4_0 0 50k
Rx4_4_1 n4_4_1 n5_4_1 1k
Ry4_4_1 n4_4_1 n4_5_1 1k
Rz4_4_1 n4_4_1 n4_4_2 1k
Rg4_4_1 n4_4_1 0 50k
Rx4_4_2 n4_4_2 n5_4_2 1k
Ry4_4_2 n4_4_2 n4_5_2 1k
Rz4_4_2 n4_4_2 n4_4_3 1k
Rg4_4_2 n4_4_2 0 50k
Rx4_4_3 n4_4_3 n5_4_3 1k
Ry4_4_3 n4_4_3 n4_5_3 1k
Rz4_4_3 n4_4_3 n4_4_4 1k
Rg4_4_3 n4_4_3 0 50k
Rx4_4_4 n4_4_4 n5_4_4 1k
Ry4_4_4 n4_4_4 n4_5_4 1k
Rz4_4_4 n4_4_4 n4_4_5 1k
Rg4_4_4 n4_4_4 0 50k
Rx4_4_5 n4_4_5 n5_4_5 1k
Ry4_4_5 n4_4_5 n4_5_5 1k
Rz4_4_5 n4_4_5 n4_4_6 1k
Rg4_4_5 n4_4_5 0 50k
Rx4_4_6 n4_4_6 n5_4_6 1k
Ry4_4_6 n4_4_6 n4_5_6 1k
Rz4_4_6 n4_4_6 n4_4_7 1k
Rg4_4_6 n4_4_6 0 50k
Rx4_4_7 n4_4_7 n5_4_7 1k
Ry4_4_7 n4_4_7 n4_5_7 1k
Rg4_4_7 n4_4_7 0 50k
Rx4_5_0 n4_5_0 n5_5_0 1k
Ry4_5_0 n4_5_0 n4_6_0 1k
Rz4_5_0 n4_5_0 n4_5_1 1k
Rg4_5_0 n4_5_0 0 50k
Rx4_5_1 n4_5_1 n5_5_1 1k
Ry4_5_1 n4_5_1 n4_6_1 1k
Rz4_5_1 n4_5_1 n4_5_2 1k
Rg4_5_1 n4_5_1 0 50k
Rx4_5_2 n4_5_2 n5_5_2 1k
Ry4_5_2 n4_5_2 n4_6_2 1k
Rz4_5_2 n4_5_2 n4_5_3 1k
Rg4_5_2 n4_5_2 0 50k
Rx4_5_3 n4_5_3 n5_5_3 1k
Ry4_5_3 n4_5_3 n4_6_3 1k
Rz4_5_3 n4_5_3 n4_5_4 1k
Rg4_5_3 n4_5_3 0 50k
Rx4_5_4 n4_5_4 n5_5_4 1k
Ry4_5_4 n4_5_4 n4_6_4 1k
Rz4_5_4 n4_5_4 n4_5_5 1k
Rg4_5_4 n4_5_4 0 50k
Rx4_5_5 n4_5_5 n5_5_5 1k
Ry4_5_5 n4_5_5 n4_6_5 1k
Rz4_5_5 n4_5_5 n4_5_6 1k
Rg4_5_5 n4_5_5 0 50k
Rx4_5_6 n4_5_6 n5_5_6 1k
Ry4_5_6 n4_5_6 n4_6_6 1k
Rz4_5_6 n4_5_6 n4_5_7 1k
Rg4_5_6 n4_5_6 0 50k
Rx4_5_7 n4_5_7 n5_5_7 1k
Ry4_5_7 n4_5_7 n4_6_7 1k
Rg4_5_7 n4_5_7 0 50k
Rx4_6_0 n4_6_0 n5_6_0 1k
Ry4_6_0 n4_6_0 n4_7_0 1k
Rz4_6_0 n4_6_0 n4_6_1 1k
Rg4_6_0 n4_6_0 0 50k
Rx4_6_1 n4_6_1 n5_6_1 1k
Ry4_6_1 n4_6_1 n4_7_1 1k
Rz4_6_1 n4_6_1 n4_6_2 1k
Rg4_6_1 n4_6_1 0 50k
Rx4_6_2 n4_6_2 n5_6_2 1k
Ry4_6_2 n4_6_2 n4_7_2 1k
Rz4_6_2 n4_6_2 n4_6_3 1k
Rg4_6_2 n4_6_2 0 50k
Rx4_6_3 n4_6_3 n5_6_3 1k
Ry4_6_3 n4_6_3 n4_7_3 1k
Rz4_6_3 n4_6_3 n4_6_4 1k
Rg4_6_3 n4_6_3 0 50k
Rx4_6_4 n4_6_4 n5_6_4 1k
Ry4_6_4 n4_6_4 n4_7_4 1k
Rz4_6_4 n4_6_4 n4_6_5 1k
Rg4_6_4 n4_6_4 0 50k
Rx4_6_5 n4_6_5 n5_6_5 1k
Ry4_6_5 n4_6_5 n4_7_5 1k
Rz4_6_5 n4_6_5 n4_6_6 1k
Rg4_6_5 n4_6_5 0 50k
Rx4_6_6 n4_6_6 n5_6_6 1k
Ry4_6_6 n4_6_6 n4_7_6 1k
Rz4_6_6 n4_6_6 n4_6_7 1k
Rg4_6_6 n4_6_6 0 50k
Rx4_6_7 n4_6_7 n5_6_7 1k
Ry4_6_7 n4_6_7 n4_7_7 1k
Rg4_6_7 n4_6_7 0 50k
Rx4_7_0 n4_7_0 n5_7_0 1k
Rz4_7_0 n4_7_0 n4_7_1 1k
Rg4_7_0 n4_7_0 0 50k
Rx4_7_1 n4_7_1 n5_7_1 1k
Rz4_7_1 n4_7_1 n4_7_2 1k
Rg4_7_1 n4_7_1 0 50k
Rx4_7_2 n4_7_2 n5_7_2 1k
Rz4_7_2 n4_7_2 n4_7_3 1k
Rg4_7_2 n4_7_2 0 50k
Rx4_7_3 n4_7_3 n5_7_3 1k
Rz4_7_3 n4_7_3 n4_7_4 1k
Rg4_7_3 n4_7_3 0 50k
Rx4_7_4 n4_7_4 n5_7_4 1k
Rz4_7_4 n4_7_4 n4_7_5 1k
Rg4_7_4 n4_7_4 0 50k
Rx4_7_5 n4_7_5 n5_7_5 1k
Rz4_7_5 n4_7_5 n4_7_6 1k
Rg4_7_5 n4_7_5 0 50k
Rx4_7_6 n4_7_6 n5_7_6 1k
Rz4_7_6 n4_7_6 n4_7_7 1k
Rg4_7_6 n4_7_6 0 50k
Rx4_7_7 n4_7_7 n5_7_7 1k
Rg4_7_7 n4_7_7 0 50k
Rx5_0_0 n5_0_0 n6_0_0 1k
Ry5_0_0 n5_0_0 n5_1_0 1k
Rz5_0_0 n5_0_0 n5_0_1 1k
Rg5_0_0 n5_0_0 0 50k
Rx5_0_1 n5_0_1 n6_0_1 1k
Ry5_0_1 n5_0_1 n5_1_1 1k
Rz5_0_1 n5_0_1 n5_0_2 1k
Rg5_0_1 n5_0_1 0 50k
Rx5_0_2 n5_0_2 n6_0_2 1k
Ry5_0_2 n5_0_2 n5_1_2 1k
Rz5_0_2 n5_0_2 n5_0_3 1k
Rg5_0_2 n5_0_2 0 50k
Rx5_0_3 n5_0_3 n6_0_3 1k
Ry5_0_3 n5_0_3 n5_1_3 1k
Rz5_0_3 n5_0_3 n5_0_4 1k
Rg5_0_3 n5_0_3 0 50k
Rx5_0_4 n5_0_4 n6_0_4 1k
Ry5_0_4 n5_0_4 n5_1_4 1k
Rz5_0_4 n5_0_4 n5_0_5 1k
Rg5_0_4 n5_0_4 0 50k
Rx5_0_5 n5_0_5 n6_0_5 1k
Ry5_0_5 n5_0_5 n5_1_5 1k
Rz5_0_5 n5_0_5 n5_0_6 1k
Rg5_0_5 n5_0_5 0 50k
Rx5_0_6 n5_0_6 n6_0_6 1k
Ry5_0_6 n5_0_6 n5_1_6 1k
Rz5_0_6 n5_0_6 n5_0_7 1k
Rg5_0_6 n5_0_6 0 50k
Rx5_0_7 n5_0_7 n6_0_7 1k
Ry5_0_7 n5_0_7 n5_1_7 1k
Rg5_0_7 n5_0_7 0 50k
Rx5_1_0 n5_1_0 n6_1_0 1k
Ry5_1_0 n5_1_0 n5_2_0 1k
Rz5_1_0 n5_1_0 n5_1_1 1k
Rg5_1_0 n5_1_0 0 50k
Rx5_1_1 n5_1_1 n6_1_1 1k
Ry5_1_1 n5_1_1 n5_2_1 1k
Rz5_1_1 n5_1_1 n5_1_2 1k
Rg5_1_1 n5_1_1 0 50k
Rx5_1_2 n5_1_2 n6_1_2 1k
Ry5_1_2 n5_1_2 n5_2_2 1k
Rz5_1_2 n5_1_2 n5_1_3 1k
Rg5_1_2 n5_1_2 0 50k
Rx5_1_3 n5_1_3 n6_1_3 1k
Ry5_1_3 n5_1_3 n5_2_3 1k
Rz5_1_3 n5_1_3 n5_1_4 1k
Rg5_1_3 n5_1_3 0 50k
Rx5_1_4 n5_1_4 n6_1_4 1k
Ry5_1_4 n5_1_4 n5_2_4 1k
Rz5_1_4 n5_1_4 n5_1_5 1k
Rg5_1_4 n5_1_4 0 50k
Rx5_1_5 n5_1_5 n6_1_5 1k
Ry5_1_5 n5_1_5 n5_2_5 1k
Rz5_1_5 n5_1_5 n5_1_6 1k
Rg5_1_5 n5_1_5 0 50k
Rx5_1_6 n5_1_6 n6_1_6 1k
Ry5_1_6 n5_1_6 n5_2_6 1k
Rz5_1_6 n5_1_6 n5_1_7 1k
Rg5_1_6 n5_1_6 0 50k
Rx5_1_7 n5_1_7 n6_1_7 1k
Ry5_1_7 n5_1_7 n5_2_7 1k
Rg5_1_7 n5_1_7 0 50k
Rx5_2_0 n5_2_0 n6_2_0 1k
Ry5_2_0 n5_2_0 n5_3_0 1k
Rz5_2_0 n5_2_0 n5_2_1 1k
Rg5_2_0 n5_2_0 0 50k
Rx5_2_1 n5_2_1 n6_2_1 1k
Ry5_2_1 n5_2_1 n5_3_1 1k
Rz5_2_1 n5_2_1 n5_2_2 1k
Rg5_2_1 n5_2_1 0 50k
Rx5_2_2 n5_2_2 n6_2_2 1k
Ry5_2_2 n5_2_2 n5_3_2 1k
Rz5_2_2 n5_2_2 n5_2_3 1k
Rg5_2_2 n5_2_2 0 50k
Rx5_2_3 n5_2_3 n6_2_3 1k
Ry5_2_3 n5_2_3 n5_3_3 1k
Rz5_2_3 n5_2_3 n5_2_4 1k
Rg5_2_3 n5_2_3 0 50k
Rx5_2_4 n5_2_4 n6_2_4 1k
Ry5_2_4 n5_2_4 n5_3_4 1k
Rz5_2_4 n5_2_4 n5_2_5 1k
Rg5_2_4 n5_2_4 0 50k
Rx5_2_5 n5_2_5 n6_2_5 1k
Ry5_2_5 n5_2_5 n5_3_5 1k
Rz5_2_5 n5_2_5 n5_2_6 1k
Rg5_2_5 n5_2_5 0 50k
Rx5_2_6 n5_2_6 n6_2_6 1k
Ry5_2_6 n5_2_6 n5_3_6 1k
Rz5_2_6 n5_2_6 n5_2_7 1k
Rg5_2_6 n5_2_6 0 50k
Rx5_2_7 n5_2_7 n6_2_7 1k
Ry5_2_7 n5_2_7 n5_3_7 1k
Rg5_2_7 n5_2_7 0 50k
Rx5_3_0 n5_3_0 n6_3_0 1k
Ry5_3_0 n5_3_0 n5_4_0 1k
Rz5_3_0 n5_3_0 n5_3_1 1k
Rg5_3_0 n5_3_0 0 50k
Rx5_3_1 n5_3_1 n6_3_1 1k
Ry5_3_1 n5_3_1 n5_4_1 1k
Rz5_3_1 n5_3_1 n5_3_2 1k
Rg5_3_1 n5_3_1 0 50k
Rx5_3_2 n5_3_2 n6_3_2 1k
Ry5_3_2 n5_3_2 n5_4_2 1k
Rz5_3_2 n5_3_2 n5_3_3 1k
Rg5_3_2 n5_3_2 0 50k
Rx5_3_3 n5_3_3 n6_3_3 1k
Ry5_3_3 n5_3_3 n5_4_3 1k
Rz5_3_3 n5_3_3 n5_3_4 1k
Rg5_3_3 n5_3_3 0 50k
Rx5_3_4 n5_3_4 n6_3_4 1k
Ry5_3_4 n5_3_4 n5_4_4 1k
Rz5_3_4 n5_3_4 n5_3_5 1k
Rg5_3_4 n5_3_4 0 50k
Rx5_3_5 n5_3_5 n6_3_5 1k
Ry5_3_5 n5_3_5 n5_4_5 1k
Rz5_3_5 n5_3_5 n5_3_6 1k
Rg5_3_5 n5_3_5 0 50k
Rx5_3_6 n5_3_6 n6_3_6 1k
Ry5_3_6 n5_3_6 n5_4_6 1k
Rz5_3_6 n5_3_6 n5_3_7 1k
Rg5_3_6 n5_3_6 0 50k
Rx5_3_7 n5_3_7 n6_3_7 1k
Ry5_3_7 n5_3_7 n5_4_7 1k
Rg5_3_7 n5_3_7 0 50k
Rx5_4_0 n5_4_0 n6_4_0 1k
Ry5_4_0 n5_4_0 n5_5_0 1k
Rz5_4_0 n5_4_0 n5_4_1 1k
Rg5_4_0 n5_4_0 0 50k
Rx5_4_1 n5_4_1 n6_4_1 1k
Ry5_4_1 n5_4_1 n5_5_1 1k
Rz5_4_1 n5_4_1 n5_4_2 1k
Rg5_4_1 n5_4_1 0 50k
Rx5_4_2 n5_4_2 n6_4_2 1k
Ry5_4_2 n5_4_2 n5_5_2 1k
Rz5_4_2 n5_4_2 n5_4_3 1k
Rg5_4_2 n5_4_2 0 50k
Rx5_4_3 n5_4_3 n6_4_3 1k
Ry5_4_3 n5_4_3 n5_5_3 1k
Rz5_4_3 n5_4_3 n5_4_4 1k
Rg5_4_3 n5_4_3 0 50k
Rx5_4_4 n5_4_4 n6_4_4 1k
Ry5_4_4 n5_4_4 n5_5_4 1k
Rz5_4_4 n5_4_4 n5_4_5 1k
Rg5_4_4 n5_4_4 0 50k
Rx5_4_5 n5_4_5 n6_4_5 1k
Ry5_4_5 n5_4_5 n5_5_5 1k
Rz5_4_5 n5_4_5 n5_4_6 1k
Rg5_4_5 n5_4_5 0 50k
Rx5_4_6 n5_4_6 n6_4_6 1k
Ry5_4_6 n5_4_6 n5_5_6 1k
Rz5_4_6 n5_4_6 n5_4_7 1k
Rg5_4_6 n5_4_6 0 50k
Rx5_4_7 n5_4_7 n6_4_7 1k
Ry5_4_7 n5_4_7 n5_5_7 1k
Rg5_4_7 n5_4_7 0 50k
Rx5_5_0 n5_5_0 n6_5_0 1k
Ry5_5_0 n5_5_0 n5_6_0 1k
Rz5_5_0 n5_5_0 n5_5_1 1k
Rg5_5_0 n5_5_0 0 50k
Rx5_5_1 n5_5_1 n6_5_1 1k
Ry5_5_1 n5_5_1 n5_6_1 1k
Rz5_5_1 n5_5_1 n5_5_2 1k
Rg5_5_1 n5_5_1 0 50k
Rx5_5_2 n5_5_2 n6_5_2 1k
Ry5_5_2 n5_5_2 n5_6_2 1k
Rz5_5_2 n5_5_2 n5_5_3 1k
Rg5_5_2 n5_5_2 0 50k
Rx5_5_3 n5_5_3 n6_5_3 1k
Ry5_5_3 n5_5_3 n5_6_3 1k
Rz5_5_3 n5_5_3 n5_5_4 1k
Rg5_5_3 n5_5_3 0 50k
Rx5_5_4 n5_5_4 n6_5_4 1k
Ry5_5_4 n5_5_4 n5_6_4 1k
Rz5_5_4 n5_5_4 n5_5_5 1k
Rg5_5_4 n5_5_4 0 50k
Rx5_5_5 n5_5_5 n6_5_5 1k
Ry5_5_5 n5_5_5 n5_6_5 1k
Rz5_5_5 n5_5_5 n5_5_6 1k
Rg5_5_5 n5_5_5 0 50k
Rx5_5_6 n5_5_6 n6_5_6 1k
Ry5_5_6 n5_5_6 n5_6_6 1k
Rz5_5_6 n5_5_6 n5_5_7 1k
Rg5_5_6 n5_5_6 0 50k
Rx5_5_7 n5_5_7 n6_5_7 1k
Ry5_5_7 n5_5_7 n5_6_7 1k
Rg5_5_7 n5_5_7 0 50k
Rx5_6_0 n5_6_0 n6_6_0 1k
Ry5_6_0 n5_6_0 n5_7_0 1k
Rz5_6_0 n5_6_0 n5_6_1 1k
Rg5_6_0 n5_6_0 0 50k
Rx5_6_1 n5_6_1 n6_6_1 1k
Ry5_6_1 n5_6_1 n5_7_1 1k
Rz5_6_1 n5_6_1 n5_6_2 1k
Rg5_6_1 n5_6_1 0 50k
Rx5_6_2 n5_6_2 n6_6_2 1k
Ry5_6_2 n5_6_2 n5_7_2 1k
Rz5_6_2 n5_6_2 n5_6_3 1k
Rg5_6_2 n5_6_2 0 50k
Rx5_6_3 n5_6_3 n6_6_3 1k
Ry5_6_3 n5_6_3 n5_7_3 1k
Rz5_6_3 n5_6_3 n5_6_4 1k
Rg5_6_3 n5_6_3 0 50k
Rx5_6_4 n5_6_4 n6_6_4 1k
Ry5_6_4 n5_6_4 n5_7_4 1k
Rz5_6_4 n5_6_4 n5_6_5 1k
Rg5_6_4 n5_6_4 0 50k
Rx5_6_5 n5_6_5 n6_6_5 1k
Ry5_6_5 n5_6_5 n5_7_5 1k
Rz5_6_5 n5_6_5 n5_6_6 1k
Rg5_6_5 n5_6_5 0 50k
Rx5_6_6 n5_6_6 n6_6_6 1k
Ry5_6_6 n5_6_6 n5_7_6 1k
Rz5_6_6 n5_6_6 n5_6_7 1k
Rg5_6_6 n5_6_6 0 50k
Rx5_6_7 n5_6_7 n6_6_7 1k
Ry5_6_7 n5_6_7 n5_7_7 1k
Rg5_6_7 n5_6_7 0 50k
Rx5_7_0 n5_7_0 n6_7_0 1k
Rz5_7_0 n5_7_0 n5_7_1 1k
Rg5_7_0 n5_7_0 0 50k
Rx5_7_1 n5_7_1 n6_7_1 1k
Rz5_7_1 n5_7_1 n5_7_2 1k
Rg5_7_1 n5_7_1 0 50k
Rx5_7_2 n5_7_2 n6_7_2 1k
Rz5_7_2 n5_7_2 n5_7_3 1k
Rg5_7_2 n5_7_2 0 50k
Rx5_7_3 n5_7_3 n6_7_3 1k
Rz5_7_3 n5_7_3 n5_7_4 1k
Rg5_7_3 n5_7_3 0 50k
Rx5_7_4 n5_7_4 n6_7_4 1k
Rz5_7_4 n5_7_4 n5_7_5 1k
Rg5_7_4 n5_7_4 0 50k
Rx5_7_5 n5_7_5 n6_7_5 1k
Rz5_7_5 n5_7_5 n5_7_6 1k
Rg5_7_5 n5_7_5 0 50k
Rx5_7_6 n5_7_6 n6_7_6 1k
Rz5_7_6 n5_7_6 n5_7_7 1k
Rg5_7_6 n5_7_6 0 50k
Rx5_7_7 n5_7_7 n6_7_7 1k
Rg5_7_7 n5_7_7 0 50k
Rx6_0_0 n6_0_0 n7_0_0 1k
Ry6_0_0 n6_0_0 n6_1_0 1k
Rz6_0_0 n6_0_0 n6_0_1 1k
Rg6_0_0 n6_0_0 0 50k
Rx6_0_1 n6_0_1 n7_0_1 1k
Ry6_0_1 n6_0_1 n6_1_1 1k
Rz6_0_1 n6_0_1 n6_0_2 1k
Rg6_0_1 n6_0_1 0 50k
Rx6_0_2 n6_0_2 n7_0_2 1k
Ry6_0_2 n6_0_2 n6_1_2 1k
Rz6_0_2 n6_0_2 n6_0_3 1k
Rg6_0_2 n6_0_2 0 50k
Rx6_0_3 n6_0_3 n7_0_3 1k
Ry6_0_3 n6_0_3 n6_1_3 1k
Rz6_0_3 n6_0_3 n6_0_4 1k
Rg6_0_3 n6_0_3 0 50k
Rx6_0_4 n6_0_4 n7_0_4 1k
Ry6_0_4 n6_0_4 n6_1_4 1k
Rz6_0_4 n6_0_4 n6_0_5 1k
Rg6_0_4 n6_0_4 0 50k
Rx6_0_5 n6_0_5 n7_0_5 1k
Ry6_0_5 n6_0_5 n6_1_5 1k
Rz6_0_5 n6_0_5 n6_0_6 1k
Rg6_0_5 n6_0_5 0 50k
Rx6_0_6 n6_0_6 n7_0_6 1k
Ry6_0_6 n6_0_6 n6_1_6 1k
Rz6_0_6 n6_0_6 n6_0_7 1k
Rg6_0_6 n6_0_6 0 50k
Rx6_0_7 n6_0_7 n7_0_7 1k
Ry6_0_7 n6_0_7 n6_1_7 1k
Rg6_0_7 n6_0_7 0 50k
Rx6_1_0 n6_1_0 n7_1_0 1k
Ry6_1_0 n6_1_0 n6_2_0 1k
Rz6_1_0 n6_1_0 n6_1_1 1k
Rg6_1_0 n6_1_0 0 50k
Rx6_1_1 n6_1_1 n7_1_1 1k
Ry6_1_1 n6_1_1 n6_2_1 1k
Rz6_1_1 n6_1_1 n6_1_2 1k
Rg6_1_1 n6_1_1 0 50k
Rx6_1_2 n6_1_2 n7_1_2 1k
Ry6_1_2 n6_1_2 n6_2_2 1k
Rz6_1_2 n6_1_2 n6_1_3 1k
Rg6_1_2 n6_1_2 0 50k
Rx6_1_3 n6_1_3 n7_1_3 1k
Ry6_1_3 n6_1_3 n6_2_3 1k
Rz6_1_3 n6_1_3 n6_1_4 1k
Rg6_1_3 n6_1_3 0 50k
Rx6_1_4 n6_1_4 n7_1_4 1k
Ry6_1_4 n6_1_4 n6_2_4 1k
Rz6_1_4 n6_1_4 n6_1_5 1k
Rg6_1_4 n6_1_4 0 50k
Rx6_1_5 n6_1_5 n7_1_5 1k
Ry6_1_5 n6_1_5 n6_2_5 1k
Rz6_1_5 n6_1_5 n6_1_6 1k
Rg6_1_5 n6_1_5 0 50k
Rx6_1_6 n6_1_6 n7_1_6 1k
Ry6_1_6 n6_1_6 n6_2_6 1k
Rz6_1_6 n6_1_6 n6_1_7 1k
Rg6_1_6 n6_1_6 0 50k
Rx6_1_7 n6_1_7 n7_1_7 1k
Ry6_1_7 n6_1_7 n6_2_7 1k
Rg6_1_7 n6_1_7 0 50k
Rx6_2_0 n6_2_0 n7_2_0 1k
Ry6_2_0 n6_2_0 n6_3_0 1k
Rz6_2_0 n6_2_0 n6_2_1 1k
Rg6_2_0 n6_2_0 0 50k
Rx6_2_1 n6_2_1 n7_2_1 1k
Ry6_2_1 n6_2_1 n6_3_1 1k
Rz6_2_1 n6_2_1 n6_2_2 1k
Rg6_2_1 n6_2_1 0 50k
Rx6_2_2 n6_2_2 n7_2_2 1k
Ry6_2_2 n6_2_2 n6_3_2 1k
Rz6_2_2 n6_2_2 n6_2_3 1k
Rg6_2_2 n6_2_2 0 50k
Rx6_2_3 n6_2_3 n7_2_3 1k
Ry6_2_3 n6_2_3 n6_3_3 1k
Rz6_2_3 n6_2_3 n6_2_4 1k
Rg6_2_3 n6_2_3 0 50k
Rx6_2_4 n6_2_4 n7_2_4 1k
Ry6_2_4 n6_2_4 n6_3_4 1k
Rz6_2_4 n6_2_4 n6_2_5 1k
Rg6_2_4 n6_2_4 0 50k
Rx6_2_5 n6_2_5 n7_2_5 1k
Ry6_2_5 n6_2_5 n6_3_5 1k
Rz6_2_5 n6_2_5 n6_2_6 1k
Rg6_2_5 n6_2_5 0 50k
Rx6_2_6 n6_2_6 n7_2_6 1k
Ry6_2_6 n6_2_6 n6_3_6 1k
Rz6_2_6 n6_2_6 n6_2_7 1k
Rg6_2_6 n6_2_6 0 50k
Rx6_2_7 n6_2_7 n7_2_7 1k
Ry6_2_7 n6_2_7 n6_3_7 1k
Rg6_2_7 n6_2_7 0 50k
Rx6_3_0 n6_3_0 n7_3_0 1k
Ry6_3_0 n6_3_0 n6_4_0 1k
Rz6_3_0 n6_3_0 n6_3_1 1k
Rg6_3_0 n6_3_0 0 50k
Rx6_3_1 n6_3_1 n7_3_1 1k
Ry6_3_1 n6_3_1 n6_4_1 1k
Rz6_3_1 n6_3_1 n6_3_2 1k
Rg6_3_1 n6_3_1 0 50k
Rx6_3_2 n6_3_2 n7_3_2 1k
Ry6_3_2 n6_3_2 n6_4_2 1k
Rz6_3_2 n6_3_2 n6_3_3 1k
Rg6_3_2 n6_3_2 0 50k
Rx6_3_3 n6_3_3 n7_3_3 1k
Ry6_3_3 n6_3_3 n6_4_3 1k
Rz6_3_3 n6_3_3 n6_3_4 1k
Rg6_3_3 n6_3_3 0 50k
Rx6_3_4 n6_3_4 n7_3_4 1k
Ry6_3_4 n6_3_4 n6_4_4 1k
Rz6_3_4 n6_3_4 n6_3_5 1k
Rg6_3_4 n6_3_4 0 50k
Rx6_3_5 n6_3_5 n7_3_5 1k
Ry6_3_5 n6_3_5 n6_4_5 1k
Rz6_3_5 n6_3_5 n6_3_6 1k
Rg6_3_5 n6_3_5 0 50k
Rx6_3_6 n6_3_6 n7_3_6 1k
Ry6_3_6 n6_3_6 n6_4_6 1k
Rz6_3_6 n6_3_6 n6_3_7 1k
Rg6_3_6 n6_3_6 0 50k
Rx6_3_7 n6_3_7 n7_3_7 1k
Ry6_3_7 n6_3_7 n6_4_7 1k
Rg6_3_7 n6_3_7 0 50k
Rx6_4_0 n6_4_0 n7_4_0 1k
Ry6_4_0 n6_4_0 n6_5_0 1k
Rz6_4_0 n6_4_0 n6_4_1 1k
Rg6_4_0 n6_4_0 0 50k
Rx6_4_1 n6_4_1 n7_4_1 1k
Ry6_4_1 n6_4_1 n6_5_1 1k
Rz6_4_1 n6_4_1 n6_4_2 1k
Rg6_4_1 n6_4_1 0 50k
Rx6_4_2 n6_4_2 n7_4_2 1k
Ry6_4_2 n6_4_2 n6_5_2 1k
Rz6_4_2 n6_4_2 n6_4_3 1k
Rg6_4_2 n6_4_2 0 50k
Rx6_4_3 n6_4_3 n7_4_3 1k
Ry6_4_3 n6_4_3 n6_5_3 1k
Rz6_4_3 n6_4_3 n6_4_4 1k
Rg6_4_3 n6_4_3 0 50k
Rx6_4_4 n6_4_4 n7_4_4 1k
Ry6_4_4 n6_4_4 n6_5_4 1k
Rz6_4_4 n6_4_4 n6_4_5 1k
Rg6_4_4 n6_4_4 0 50k
Rx6_4_5 n6_4_5 n7_4_5 1k
Ry6_4_5 n6_4_5 n6_5_5 1k
Rz6_4_5 n6_4_5 n6_4_6 1k
Rg6_4_5 n6_4_5 0 50k
Rx6_4_6 n6_4_6 n7_4_6 1k
Ry6_4_6 n6_4_6 n6_5_6 1k
Rz6_4_6 n6_4_6 n6_4_7 1k
Rg6_4_6 n6_4_6 0 50k
Rx6_4_7 n6_4_7 n7_4_7 1k
Ry6_4_7 n6_4_7 n6_5_7 1k
Rg6_4_7 n6_4_7 0 50k
Rx6_5_0 n6_5_0 n7_5_0 1k
Ry6_5_0 n6_5_0 n6_6_0 1k
Rz6_5_0 n6_5_0 n6_5_1 1k
Rg6_5_0 n6_5_0 0 50k
Rx6_5_1 n6_5_1 n7_5_1 1k
Ry6_5_1 n6_5_1 n6_6_1 1k
Rz6_5_1 n6_5_1 n6_5_2 1k
Rg6_5_1 n6_5_1 0 50k
Rx6_5_2 n6_5_2 n7_5_2 1k
Ry6_5_2 n6_5_2 n6_6_2 1k
Rz6_5_2 n6_5_2 n6_5_3 1k
Rg6_5_2 n6_5_2 0 50k
Rx6_5_3 n6_5_3 n7_5_3 1k
Ry6_5_3 n6_5_3 n6_6_3 1k
Rz6_5_3 n6_5_3 n6_5_4 1k
Rg6_5_3 n6_5_3 0 50k
Rx6_5_4 n6_5_4 n7_5_4 1k
Ry6_5_4 n6_5_4 n6_6_4 1k
Rz6_5_4 n6_5_4 n6_5_5 1k
Rg6_5_4 n6_5_4 0 50k
Rx6_5_5 n6_5_5 n7_5_5 1k
Ry6_5_5 n6_5_5 n6_6_5 1k
Rz6_5_5 n6_5_5 n6_5_6 1k
Rg6_5_5 n6_5_5 0 50k
Rx6_5_6 n6_5_6 n7_5_6 1k
Ry6_5_6 n6_5_6 n6_6_6 1k
Rz6_5_6 n6_5_6 n6_5_7 1k
Rg6_5_6 n6_5_6 0 50k
Rx6_5_7 n6_5_7 n7_5_7 1k
Ry6_5_7 n6_5_7 n6_6_7 1k
Rg6_5_7 n6_5_7 0 50k
Rx6_6_0 n6_6_0 n7_6_0 1k
Ry6_6_0 n6_6_0 n6_7_0 1k
Rz6_6_0 n6_6_0 n6_6_1 1k
Rg6_6_0 n6_6_0 0 50k
Rx6_6_1 n6_6_1 n7_6_1 1k
Ry6_6_1 n6_6_1 n6_7_1 1k
Rz6_6_1 n6_6_1 n6_6_2 1k
Rg6_6_1 n6_6_1 0 50k
Rx6_6_2 n6_6_2 n7_6_2 1k
Ry6_6_2 n6_6_2 n6_7_2 1k
Rz6_6_2 n6_6_2 n6_6_3 1k
Rg6_6_2 n6_6_2 0 50k
Rx6_6_3 n6_6_3 n7_6_3 1k
Ry6_6_3 n6_6_3 n6_7_3 1k
Rz6_6_3 n6_6_3 n6_6_4 1k
Rg6_6_3 n6_6_3 0 50k
Rx6_6_4 n6_6_4 n7_6_4 1k
Ry6_6_4 n6_6_4 n6_7_4 1k
Rz6_6_4 n6_6_4 n6_6_5 1k
Rg6_6_4 n6_6_4 0 50k
Rx6_6_5 n6_6_5 n7_6_5 1k
Ry6_6_5 n6_6_5 n6_7_5 1k
Rz6_6_5 n6_6_5 n6_6_6 1k
Rg6_6_5 n6_6_5 0 50k
Rx6_6_6 n6_6_6 n7_6_6 1k
Ry6_6_6 n6_6_6 n6_7_6 1k
Rz6_6_6 n6_6_6 n6_6_7 1k
Rg6_6_6 n6_6_6 0 50k
Rx6_6_7 n6_6_7 n7_6_7 1k
Ry6_6_7 n6_6_7 n6_7_7 1k
Rg6_6_7 n6_6_7 0 50k
Rx6_7_0 n6_7_0 n7_7_0 1k
Rz6_7_0 n6_7_0 n6_7_1 1k
Rg6_7_0 n6_7_0 0 50k
Rx6_7_1 n6_7_1 n7_7_1 1k
Rz6_7_1 n6_7_1 n6_7_2 1k
Rg6_7_1 n6_7_1 0 50k
Rx6_7_2 n6_7_2 n7_7_2 1k
Rz6_7_2 n6_7_2 n6_7_3 1k
Rg6_7_2 n6_7_2 0 50k
Rx6_7_3 n6_7_3 n7_7_3 1k
Rz6_7_3 n6_7_3 n6_7_4 1k
Rg6_7_3 n6_7_3 0 50k
Rx6_7_4 n6_7_4 n7_7_4 1k
Rz6_7_4 n6_7_4 n6_7_5 1k
Rg6_7_4 n6_7_4 0 50k
Rx6_7_5 n6_7_5 n7_7_5 1k
Rz6_7_5 n6_7_5 n6_7_6 1k
Rg6_7_5 n6_7_5 0 50k
Rx6_7_6 n6_7_6 n7_7_6 1k
Rz6_7_6 n6_7_6 n6_7_7 1k
Rg6_7_6 n6_7_6 0 50k
Rx6_7_7 n6_7_7 n7_7_7 1k
Rg6_7_7 n6_7_7 0 50k
Ry7_0_0 n7_0_0 n7_1_0 1k
Rz7_0_0 n7_0_0 n7_0_1 1k
Rg7_0_0 n7_0_0 0 50k
Ry7_0_1 n7_0_1 n7_1_1 1k
Rz7_0_1 n7_0_1 n7_0_2 1k
Rg7_0_1 n7_0_1 0 50k
Ry7_0_2 n7_0_2 n7_1_2 1k
Rz7_0_2 n7_0_2 n7_0_3 1k
Rg7_0_2 n7_0_2 0 50k
Ry7_0_3 n7_0_3 n7_1_3 1k
Rz7_0_3 n7_0_3 n7_0_4 1k
Rg7_0_3 n7_0_3 0 50k
Ry7_0_4 n7_0_4 n7_1_4 1k
Rz7_0_4 n7_0_4 n7_0_5 1k
Rg7_0_4 n7_0_4 0 50k
Ry7_0_5 n7_0_5 n7_1_5 1k
Rz7_0_5 n7_0_5 n7_0_6 1k
Rg7_0_5 n7_0_5 0 50k
Ry7_0_6 n7_0_6 n7_1_6 1k
Rz7_0_6 n7_0_6 n7_0_7 1k
Rg7_0_6 n7_0_6 0 50k
Ry7_0_7 n7_0_7 n7_1_7 1k
Rg7_0_7 n7_0_7 0 50k
Ry7_1_0 n7_1_0 n7_2_0 1k
Rz7_1_0 n7_1_0 n7_1_1 1k
Rg7_1_0 n7_1_0 0 50k
Ry7_1_1 n7_1_1 n7_2_1 1k
Rz7_1_1 n7_1_1 n7_1_2 1k
Rg7_1_1 n7_1_1 0 50k
Ry7_1_2 n7_1_2 n7_2_2 1k
Rz7_1_2 n7_1_2 n7_1_3 1k
Rg7_1_2 n7_1_2 0 50k
Ry7_1_3 n7_1_3 n7_2_3 1k
Rz7_1_3 n7_1_3 n7_1_4 1k
Rg7_1_3 n7_1_3 0 50k
Ry7_1_4 n7_1_4 n7_2_4 1k
Rz7_1_4 n7_1_4 n7_1_5 1k
Rg7_1_4 n7_1_4 0 50k
Ry7_1_5 n7_1_5 n7_2_5 1k
Rz7_1_5 n7_1_5 n7_1_6 1k
Rg7_1_5 n7_1_5 0 50k
Ry7_1_6 n7_1_6 n7_2_6 1k
Rz7_1_6 n7_1_6 n7_1_7 1k
Rg7_1_6 n7_1_6 0 50k
Ry7_1_7 n7_1_7 n7_2_7 1k
Rg7_1_7 n7_1_7 0 50k
Ry7_2_0 n7_2_0 n7_3_0 1k
Rz7_2_0 n7_2_0 n7_2_1 1k
Rg7_2_0 n7_2_0 0 50k
Ry7_2_1 n7_2_1 n7_3_1 1k
Rz7_2_1 n7_2_1 n7_2_2 1k
Rg7_2_1 n7_2_1 0 50k
Ry7_2_2 n7_2_2 n7_3_2 1k
Rz7_2_2 n7_2_2 n7_2_3 1k
Rg7_2_2 n7_2_2 0 50k
Ry7_2_3 n7_2_3 n7_3_3 1k
Rz7_2_3 n7_2_3 n7_2_4 1k
Rg7_2_3 n7_2_3 0 50k
Ry7_2_4 n7_2_4 n7_3_4 1k
Rz7_2_4 n7_2_4 n7_2_5 1k
Rg7_2_4 n7_2_4 0 50k
Ry7_2_5 n7_2_5 n7_3_5 1k
Rz7_2_5 n7_2_5 n7_2_6 1k
Rg7_2_5 n7_2_5 0 50k
Ry7_2_6 n7_2_6 n7_3_6 1k
Rz7_2_6 n7_2_6 n7_2_7 1k
Rg7_2_6 n7_2_6 0 50k
Ry7_2_7 n7_2_7 n7_3_7 1k
Rg7_2_7 n7_2_7 0 50k
Ry7_3_0 n7_3_0 n7_4_0 1k
Rz7_3_0 n7_3_0 n7_3_1 1k
Rg7_3_0 n7_3_0 0 50k
Ry7_3_1 n7_3_1 n7_4_1 1k
Rz7_3_1 n7_3_1 n7_3_2 1k
Rg7_3_1 n7_3_1 0 50k
Ry7_3_2 n7_3_2 n7_4_2 1k
Rz7_3_2 n7_3_2 n7_3_3 1k
Rg7_3_2 n7_3_2 0 50k
Ry7_3_3 n7_3_3 n7_4_3 1k
Rz7_3_3 n7_3_3 n7_3_4 1k
Rg7_3_3 n7_3_3 0 50k
Ry7_3_4 n7_3_4 n7_4_4 1k
Rz7_3_4 n7_3_4 n7_3_5 1k
Rg7_3_4 n7_3_4 0 50k
Ry7_3_5 n7_3_5 n7_4_5 1k
Rz7_3_5 n7_3_5 n7_3_6 1k
Rg7_3_5 n7_3_5 0 50k
Ry7_3_6 n7_3_6 n7_4_6 1k
Rz7_3_6 n7_3_6 n7_3_7 1k
Rg7_3_6 n7_3_6 0 50k
Ry7_3_7 n7_3_7 n7_4_7 1k
Rg7_3_7 n7_3_7 0 50k
Ry7_4_0 n7_4_0 n7_5_0 1k
Rz7_4_0 n7_4_0 n7_4_1 1k
Rg7_4_0 n7_4_0 0 50k
Ry7_4_1 n7_4_1 n7_5_1 1k
Rz7_4_1 n7_4_1 n7_4_2 1k
Rg7_4_1 n7_4_1 0 50k
Ry7_4_2 n7_4_2 n7_5_2 1k
Rz7_4_2 n7_4_2 n7_4_3 1k
Rg7_4_2 n7_4_2 0 50k
Ry7_4_3 n7_4_3 n7_5_3 1k
Rz7_4_3 n7_4_3 n7_4_4 1k
Rg7_4_3 n7_4_3 0 50k
Ry7_4_4 n7_4_4 n7_5_4 1k
Rz7_4_4 n7_4_4 n7_4_5 1k
Rg7_4_4 n7_4_4 0 50k
Ry7_4_5 n7_4_5 n7_5_5 1k
Rz7_4_5 n7_4_5 n7_4_6 1k
Rg7_4_5 n7_4_5 0 50k
Ry7_4_6 n7_4_6 n7_5_6 1k
Rz7_4_6 n7_4_6 n7_4_7 1k
Rg7_4_6 n7_4_6 0 50k
Ry7_4_7 n7_4_7 n7_5_7 1k
Rg7_4_7 n7_4_7 0 50k
Ry7_5_0 n7_5_0 n7_6_0 1k
Rz7_5_0 n7_5_0 n7_5_1 1k
Rg7_5_0 n7_5_0 0 50k
Ry7_5_1 n7_5_1 n7_6_1 1k
Rz7_5_1 n7_5_1 n7_5_2 1k
Rg7_5_1 n7_5_1 0 50k
Ry7_5_2 n7_5_2 n7_6_2 1k
Rz7_5_2 n7_5_2 n7_5_3 1k
Rg7_5_2 n7_5_2 0 50k
Ry7_5_3 n7_5_3 n7_6_3 1k
Rz7_5_3 n7_5_3 n7_5_4 1k
Rg7_5_3 n7_5_3 0 50k
Ry7_5_4 n7_5_4 n7_6_4 1k
Rz7_5_4 n7_5_4 n7_5_5 1k
Rg7_5_4 n7_5_4 0 50k
Ry7_5_5 n7_5_5 n7_6_5 1k
Rz7_5_5 n7_5_5 n7_5_6 1k
Rg7_5_5 n7_5_5 0 50k
Ry7_5_6 n7_5_6 n7_6_6 1k
Rz7_5_6 n7_5_6 n7_5_7 1k
Rg7_5_6 n7_5_6 0 50k
Ry7_5_7 n7_5_7 n7_6_7 1k
Rg7_5_7 n7_5_7 0 50k
Ry7_6_0 n7_6_0 n7_7_0 1k
Rz7_6_0 n7_6_0 n7_6_1 1k
Rg7_6_0 n7_6_0 0 50k
Ry7_6_1 n7_6_1 n7_7_1 1k
Rz7_6_1 n7_6_1 n7_6_2 1k
Rg7_6_1 n7_6_1 0 50k
Ry7_6_2 n7_6_2 n7_7_2 1k
Rz7_6_2 n7_6_2 n7_6_3 1k
Rg7_6_2 n7_6_2 0 50k
Ry7_6_3 n7_6_3 n7_7_3 1k
Rz7_6_3 n7_6_3 n7_6_4 1k
Rg7_6_3 n7_6_3 0 50k
Ry7_6_4 n7_6_4 n7_7_4 1k
Rz7_6_4 n7_6_4 n7_6_5 1k
Rg7_6_4 n7_6_4 0 50k
Ry7_6_5 n7_6_5 n7_7_5 1k
Rz7_6_5 n7_6_5 n7_6_6 1k
Rg7_6_5 n7_6_5 0 50k
Ry7_6_6 n7_6_6 n7_7_6 1k
Rz7_6_6 n7_6_6 n7_6_7 1k
Rg7_6_6 n7_6_6 0 50k
Ry7_6_7 n7_6_7 n7_7_7 1k
Rg7_6_7 n7_6_7 0 50k
Rz7_7_0 n7_7_0 n7_7_1 1k
Rg7_7_0 n7_7_0 0 50k
Rz7_7_1 n7_7_1 n7_7_2 1k
Rg7_7_1 n7_7_1 0 50k
Rz7_7_2 n7_7_2 n7_7_3 1k
Rg7_7_2 n7_7_2 0 50k
Rz7_7_3 n7_7_3 n7_7_4 1k
Rg7_7_3 n7_7_3 0 50k
Rz7_7_4 n7_7_4 n7_7_5 1k
Rg7_7_4 n7_7_4 0 50k
Rz7_7_5 n7_7_5 n7_7_6 1k
Rg7_7_5 n7_7_5 0 50k
Rz7_7_6 n7_7_6 n7_7_7 1k
Rg7_7_6 n7_7_6 0 50k
Rg7_7_7 n7_7_7 0 50k
.op
.end
