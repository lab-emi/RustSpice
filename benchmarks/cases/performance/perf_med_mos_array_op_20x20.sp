NMOS common-source array 20x20 on resistive supply and gate grids, one operating point
* bench.id: perf_med_mos_array_op_20x20
* bench.group: performance
* bench.title: NMOS common-source array 20x20 on resistive supply and gate grids, one operating point
* bench.probes: v(d0_0), v(d10_10), v(d19_19), i(vdd)
* bench.tol.rel: 1e-6
* bench.tol.abs: 1e-9
* bench.expect: match
* bench.ng.solver: both
* bench.timing: yes
* bench.size: 1204
* bench.est_rss_mib: 40
* bench.tags: nonlinear, op, mos, array, mesh, medium, faer_tier
* bench.note: four times the cells of perf_med_mos_array_op_10x10 on the same grid structure: the nonlinear 2-D system is large enough to leave the unrolled LU tier
.model nm NMOS(LEVEL=1 VTO=0.7 KP=100u LAMBDA=0.02)
VDD vdd 0 3.3
VG gin 0 1.3
Rvd vdd p0_0 5
Rvg gin g0_0 50
RD0_0 p0_0 d0_0 5k
M0_0 d0_0 g0_0 0 0 nm W=10u L=1u
Rpv0_0 p0_0 p0_1 20
Rgv0_0 g0_0 g0_1 200
Rph0_0 p0_0 p1_0 20
Rgh0_0 g0_0 g1_0 200
RD0_1 p0_1 d0_1 5k
M0_1 d0_1 g0_1 0 0 nm W=10u L=1u
Rpv0_1 p0_1 p0_2 20
Rgv0_1 g0_1 g0_2 200
Rph0_1 p0_1 p1_1 20
Rgh0_1 g0_1 g1_1 200
RD0_2 p0_2 d0_2 5k
M0_2 d0_2 g0_2 0 0 nm W=10u L=1u
Rpv0_2 p0_2 p0_3 20
Rgv0_2 g0_2 g0_3 200
Rph0_2 p0_2 p1_2 20
Rgh0_2 g0_2 g1_2 200
RD0_3 p0_3 d0_3 5k
M0_3 d0_3 g0_3 0 0 nm W=10u L=1u
Rpv0_3 p0_3 p0_4 20
Rgv0_3 g0_3 g0_4 200
Rph0_3 p0_3 p1_3 20
Rgh0_3 g0_3 g1_3 200
RD0_4 p0_4 d0_4 5k
M0_4 d0_4 g0_4 0 0 nm W=10u L=1u
Rpv0_4 p0_4 p0_5 20
Rgv0_4 g0_4 g0_5 200
Rph0_4 p0_4 p1_4 20
Rgh0_4 g0_4 g1_4 200
RD0_5 p0_5 d0_5 5k
M0_5 d0_5 g0_5 0 0 nm W=10u L=1u
Rpv0_5 p0_5 p0_6 20
Rgv0_5 g0_5 g0_6 200
Rph0_5 p0_5 p1_5 20
Rgh0_5 g0_5 g1_5 200
RD0_6 p0_6 d0_6 5k
M0_6 d0_6 g0_6 0 0 nm W=10u L=1u
Rpv0_6 p0_6 p0_7 20
Rgv0_6 g0_6 g0_7 200
Rph0_6 p0_6 p1_6 20
Rgh0_6 g0_6 g1_6 200
RD0_7 p0_7 d0_7 5k
M0_7 d0_7 g0_7 0 0 nm W=10u L=1u
Rpv0_7 p0_7 p0_8 20
Rgv0_7 g0_7 g0_8 200
Rph0_7 p0_7 p1_7 20
Rgh0_7 g0_7 g1_7 200
RD0_8 p0_8 d0_8 5k
M0_8 d0_8 g0_8 0 0 nm W=10u L=1u
Rpv0_8 p0_8 p0_9 20
Rgv0_8 g0_8 g0_9 200
Rph0_8 p0_8 p1_8 20
Rgh0_8 g0_8 g1_8 200
RD0_9 p0_9 d0_9 5k
M0_9 d0_9 g0_9 0 0 nm W=10u L=1u
Rpv0_9 p0_9 p0_10 20
Rgv0_9 g0_9 g0_10 200
Rph0_9 p0_9 p1_9 20
Rgh0_9 g0_9 g1_9 200
RD0_10 p0_10 d0_10 5k
M0_10 d0_10 g0_10 0 0 nm W=10u L=1u
Rpv0_10 p0_10 p0_11 20
Rgv0_10 g0_10 g0_11 200
Rph0_10 p0_10 p1_10 20
Rgh0_10 g0_10 g1_10 200
RD0_11 p0_11 d0_11 5k
M0_11 d0_11 g0_11 0 0 nm W=10u L=1u
Rpv0_11 p0_11 p0_12 20
Rgv0_11 g0_11 g0_12 200
Rph0_11 p0_11 p1_11 20
Rgh0_11 g0_11 g1_11 200
RD0_12 p0_12 d0_12 5k
M0_12 d0_12 g0_12 0 0 nm W=10u L=1u
Rpv0_12 p0_12 p0_13 20
Rgv0_12 g0_12 g0_13 200
Rph0_12 p0_12 p1_12 20
Rgh0_12 g0_12 g1_12 200
RD0_13 p0_13 d0_13 5k
M0_13 d0_13 g0_13 0 0 nm W=10u L=1u
Rpv0_13 p0_13 p0_14 20
Rgv0_13 g0_13 g0_14 200
Rph0_13 p0_13 p1_13 20
Rgh0_13 g0_13 g1_13 200
RD0_14 p0_14 d0_14 5k
M0_14 d0_14 g0_14 0 0 nm W=10u L=1u
Rpv0_14 p0_14 p0_15 20
Rgv0_14 g0_14 g0_15 200
Rph0_14 p0_14 p1_14 20
Rgh0_14 g0_14 g1_14 200
RD0_15 p0_15 d0_15 5k
M0_15 d0_15 g0_15 0 0 nm W=10u L=1u
Rpv0_15 p0_15 p0_16 20
Rgv0_15 g0_15 g0_16 200
Rph0_15 p0_15 p1_15 20
Rgh0_15 g0_15 g1_15 200
RD0_16 p0_16 d0_16 5k
M0_16 d0_16 g0_16 0 0 nm W=10u L=1u
Rpv0_16 p0_16 p0_17 20
Rgv0_16 g0_16 g0_17 200
Rph0_16 p0_16 p1_16 20
Rgh0_16 g0_16 g1_16 200
RD0_17 p0_17 d0_17 5k
M0_17 d0_17 g0_17 0 0 nm W=10u L=1u
Rpv0_17 p0_17 p0_18 20
Rgv0_17 g0_17 g0_18 200
Rph0_17 p0_17 p1_17 20
Rgh0_17 g0_17 g1_17 200
RD0_18 p0_18 d0_18 5k
M0_18 d0_18 g0_18 0 0 nm W=10u L=1u
Rpv0_18 p0_18 p0_19 20
Rgv0_18 g0_18 g0_19 200
Rph0_18 p0_18 p1_18 20
Rgh0_18 g0_18 g1_18 200
RD0_19 p0_19 d0_19 5k
M0_19 d0_19 g0_19 0 0 nm W=10u L=1u
Rph0_19 p0_19 p1_19 20
Rgh0_19 g0_19 g1_19 200
RD1_0 p1_0 d1_0 5k
M1_0 d1_0 g1_0 0 0 nm W=10u L=1u
Rpv1_0 p1_0 p1_1 20
Rgv1_0 g1_0 g1_1 200
Rph1_0 p1_0 p2_0 20
Rgh1_0 g1_0 g2_0 200
RD1_1 p1_1 d1_1 5k
M1_1 d1_1 g1_1 0 0 nm W=10u L=1u
Rpv1_1 p1_1 p1_2 20
Rgv1_1 g1_1 g1_2 200
Rph1_1 p1_1 p2_1 20
Rgh1_1 g1_1 g2_1 200
RD1_2 p1_2 d1_2 5k
M1_2 d1_2 g1_2 0 0 nm W=10u L=1u
Rpv1_2 p1_2 p1_3 20
Rgv1_2 g1_2 g1_3 200
Rph1_2 p1_2 p2_2 20
Rgh1_2 g1_2 g2_2 200
RD1_3 p1_3 d1_3 5k
M1_3 d1_3 g1_3 0 0 nm W=10u L=1u
Rpv1_3 p1_3 p1_4 20
Rgv1_3 g1_3 g1_4 200
Rph1_3 p1_3 p2_3 20
Rgh1_3 g1_3 g2_3 200
RD1_4 p1_4 d1_4 5k
M1_4 d1_4 g1_4 0 0 nm W=10u L=1u
Rpv1_4 p1_4 p1_5 20
Rgv1_4 g1_4 g1_5 200
Rph1_4 p1_4 p2_4 20
Rgh1_4 g1_4 g2_4 200
RD1_5 p1_5 d1_5 5k
M1_5 d1_5 g1_5 0 0 nm W=10u L=1u
Rpv1_5 p1_5 p1_6 20
Rgv1_5 g1_5 g1_6 200
Rph1_5 p1_5 p2_5 20
Rgh1_5 g1_5 g2_5 200
RD1_6 p1_6 d1_6 5k
M1_6 d1_6 g1_6 0 0 nm W=10u L=1u
Rpv1_6 p1_6 p1_7 20
Rgv1_6 g1_6 g1_7 200
Rph1_6 p1_6 p2_6 20
Rgh1_6 g1_6 g2_6 200
RD1_7 p1_7 d1_7 5k
M1_7 d1_7 g1_7 0 0 nm W=10u L=1u
Rpv1_7 p1_7 p1_8 20
Rgv1_7 g1_7 g1_8 200
Rph1_7 p1_7 p2_7 20
Rgh1_7 g1_7 g2_7 200
RD1_8 p1_8 d1_8 5k
M1_8 d1_8 g1_8 0 0 nm W=10u L=1u
Rpv1_8 p1_8 p1_9 20
Rgv1_8 g1_8 g1_9 200
Rph1_8 p1_8 p2_8 20
Rgh1_8 g1_8 g2_8 200
RD1_9 p1_9 d1_9 5k
M1_9 d1_9 g1_9 0 0 nm W=10u L=1u
Rpv1_9 p1_9 p1_10 20
Rgv1_9 g1_9 g1_10 200
Rph1_9 p1_9 p2_9 20
Rgh1_9 g1_9 g2_9 200
RD1_10 p1_10 d1_10 5k
M1_10 d1_10 g1_10 0 0 nm W=10u L=1u
Rpv1_10 p1_10 p1_11 20
Rgv1_10 g1_10 g1_11 200
Rph1_10 p1_10 p2_10 20
Rgh1_10 g1_10 g2_10 200
RD1_11 p1_11 d1_11 5k
M1_11 d1_11 g1_11 0 0 nm W=10u L=1u
Rpv1_11 p1_11 p1_12 20
Rgv1_11 g1_11 g1_12 200
Rph1_11 p1_11 p2_11 20
Rgh1_11 g1_11 g2_11 200
RD1_12 p1_12 d1_12 5k
M1_12 d1_12 g1_12 0 0 nm W=10u L=1u
Rpv1_12 p1_12 p1_13 20
Rgv1_12 g1_12 g1_13 200
Rph1_12 p1_12 p2_12 20
Rgh1_12 g1_12 g2_12 200
RD1_13 p1_13 d1_13 5k
M1_13 d1_13 g1_13 0 0 nm W=10u L=1u
Rpv1_13 p1_13 p1_14 20
Rgv1_13 g1_13 g1_14 200
Rph1_13 p1_13 p2_13 20
Rgh1_13 g1_13 g2_13 200
RD1_14 p1_14 d1_14 5k
M1_14 d1_14 g1_14 0 0 nm W=10u L=1u
Rpv1_14 p1_14 p1_15 20
Rgv1_14 g1_14 g1_15 200
Rph1_14 p1_14 p2_14 20
Rgh1_14 g1_14 g2_14 200
RD1_15 p1_15 d1_15 5k
M1_15 d1_15 g1_15 0 0 nm W=10u L=1u
Rpv1_15 p1_15 p1_16 20
Rgv1_15 g1_15 g1_16 200
Rph1_15 p1_15 p2_15 20
Rgh1_15 g1_15 g2_15 200
RD1_16 p1_16 d1_16 5k
M1_16 d1_16 g1_16 0 0 nm W=10u L=1u
Rpv1_16 p1_16 p1_17 20
Rgv1_16 g1_16 g1_17 200
Rph1_16 p1_16 p2_16 20
Rgh1_16 g1_16 g2_16 200
RD1_17 p1_17 d1_17 5k
M1_17 d1_17 g1_17 0 0 nm W=10u L=1u
Rpv1_17 p1_17 p1_18 20
Rgv1_17 g1_17 g1_18 200
Rph1_17 p1_17 p2_17 20
Rgh1_17 g1_17 g2_17 200
RD1_18 p1_18 d1_18 5k
M1_18 d1_18 g1_18 0 0 nm W=10u L=1u
Rpv1_18 p1_18 p1_19 20
Rgv1_18 g1_18 g1_19 200
Rph1_18 p1_18 p2_18 20
Rgh1_18 g1_18 g2_18 200
RD1_19 p1_19 d1_19 5k
M1_19 d1_19 g1_19 0 0 nm W=10u L=1u
Rph1_19 p1_19 p2_19 20
Rgh1_19 g1_19 g2_19 200
RD2_0 p2_0 d2_0 5k
M2_0 d2_0 g2_0 0 0 nm W=10u L=1u
Rpv2_0 p2_0 p2_1 20
Rgv2_0 g2_0 g2_1 200
Rph2_0 p2_0 p3_0 20
Rgh2_0 g2_0 g3_0 200
RD2_1 p2_1 d2_1 5k
M2_1 d2_1 g2_1 0 0 nm W=10u L=1u
Rpv2_1 p2_1 p2_2 20
Rgv2_1 g2_1 g2_2 200
Rph2_1 p2_1 p3_1 20
Rgh2_1 g2_1 g3_1 200
RD2_2 p2_2 d2_2 5k
M2_2 d2_2 g2_2 0 0 nm W=10u L=1u
Rpv2_2 p2_2 p2_3 20
Rgv2_2 g2_2 g2_3 200
Rph2_2 p2_2 p3_2 20
Rgh2_2 g2_2 g3_2 200
RD2_3 p2_3 d2_3 5k
M2_3 d2_3 g2_3 0 0 nm W=10u L=1u
Rpv2_3 p2_3 p2_4 20
Rgv2_3 g2_3 g2_4 200
Rph2_3 p2_3 p3_3 20
Rgh2_3 g2_3 g3_3 200
RD2_4 p2_4 d2_4 5k
M2_4 d2_4 g2_4 0 0 nm W=10u L=1u
Rpv2_4 p2_4 p2_5 20
Rgv2_4 g2_4 g2_5 200
Rph2_4 p2_4 p3_4 20
Rgh2_4 g2_4 g3_4 200
RD2_5 p2_5 d2_5 5k
M2_5 d2_5 g2_5 0 0 nm W=10u L=1u
Rpv2_5 p2_5 p2_6 20
Rgv2_5 g2_5 g2_6 200
Rph2_5 p2_5 p3_5 20
Rgh2_5 g2_5 g3_5 200
RD2_6 p2_6 d2_6 5k
M2_6 d2_6 g2_6 0 0 nm W=10u L=1u
Rpv2_6 p2_6 p2_7 20
Rgv2_6 g2_6 g2_7 200
Rph2_6 p2_6 p3_6 20
Rgh2_6 g2_6 g3_6 200
RD2_7 p2_7 d2_7 5k
M2_7 d2_7 g2_7 0 0 nm W=10u L=1u
Rpv2_7 p2_7 p2_8 20
Rgv2_7 g2_7 g2_8 200
Rph2_7 p2_7 p3_7 20
Rgh2_7 g2_7 g3_7 200
RD2_8 p2_8 d2_8 5k
M2_8 d2_8 g2_8 0 0 nm W=10u L=1u
Rpv2_8 p2_8 p2_9 20
Rgv2_8 g2_8 g2_9 200
Rph2_8 p2_8 p3_8 20
Rgh2_8 g2_8 g3_8 200
RD2_9 p2_9 d2_9 5k
M2_9 d2_9 g2_9 0 0 nm W=10u L=1u
Rpv2_9 p2_9 p2_10 20
Rgv2_9 g2_9 g2_10 200
Rph2_9 p2_9 p3_9 20
Rgh2_9 g2_9 g3_9 200
RD2_10 p2_10 d2_10 5k
M2_10 d2_10 g2_10 0 0 nm W=10u L=1u
Rpv2_10 p2_10 p2_11 20
Rgv2_10 g2_10 g2_11 200
Rph2_10 p2_10 p3_10 20
Rgh2_10 g2_10 g3_10 200
RD2_11 p2_11 d2_11 5k
M2_11 d2_11 g2_11 0 0 nm W=10u L=1u
Rpv2_11 p2_11 p2_12 20
Rgv2_11 g2_11 g2_12 200
Rph2_11 p2_11 p3_11 20
Rgh2_11 g2_11 g3_11 200
RD2_12 p2_12 d2_12 5k
M2_12 d2_12 g2_12 0 0 nm W=10u L=1u
Rpv2_12 p2_12 p2_13 20
Rgv2_12 g2_12 g2_13 200
Rph2_12 p2_12 p3_12 20
Rgh2_12 g2_12 g3_12 200
RD2_13 p2_13 d2_13 5k
M2_13 d2_13 g2_13 0 0 nm W=10u L=1u
Rpv2_13 p2_13 p2_14 20
Rgv2_13 g2_13 g2_14 200
Rph2_13 p2_13 p3_13 20
Rgh2_13 g2_13 g3_13 200
RD2_14 p2_14 d2_14 5k
M2_14 d2_14 g2_14 0 0 nm W=10u L=1u
Rpv2_14 p2_14 p2_15 20
Rgv2_14 g2_14 g2_15 200
Rph2_14 p2_14 p3_14 20
Rgh2_14 g2_14 g3_14 200
RD2_15 p2_15 d2_15 5k
M2_15 d2_15 g2_15 0 0 nm W=10u L=1u
Rpv2_15 p2_15 p2_16 20
Rgv2_15 g2_15 g2_16 200
Rph2_15 p2_15 p3_15 20
Rgh2_15 g2_15 g3_15 200
RD2_16 p2_16 d2_16 5k
M2_16 d2_16 g2_16 0 0 nm W=10u L=1u
Rpv2_16 p2_16 p2_17 20
Rgv2_16 g2_16 g2_17 200
Rph2_16 p2_16 p3_16 20
Rgh2_16 g2_16 g3_16 200
RD2_17 p2_17 d2_17 5k
M2_17 d2_17 g2_17 0 0 nm W=10u L=1u
Rpv2_17 p2_17 p2_18 20
Rgv2_17 g2_17 g2_18 200
Rph2_17 p2_17 p3_17 20
Rgh2_17 g2_17 g3_17 200
RD2_18 p2_18 d2_18 5k
M2_18 d2_18 g2_18 0 0 nm W=10u L=1u
Rpv2_18 p2_18 p2_19 20
Rgv2_18 g2_18 g2_19 200
Rph2_18 p2_18 p3_18 20
Rgh2_18 g2_18 g3_18 200
RD2_19 p2_19 d2_19 5k
M2_19 d2_19 g2_19 0 0 nm W=10u L=1u
Rph2_19 p2_19 p3_19 20
Rgh2_19 g2_19 g3_19 200
RD3_0 p3_0 d3_0 5k
M3_0 d3_0 g3_0 0 0 nm W=10u L=1u
Rpv3_0 p3_0 p3_1 20
Rgv3_0 g3_0 g3_1 200
Rph3_0 p3_0 p4_0 20
Rgh3_0 g3_0 g4_0 200
RD3_1 p3_1 d3_1 5k
M3_1 d3_1 g3_1 0 0 nm W=10u L=1u
Rpv3_1 p3_1 p3_2 20
Rgv3_1 g3_1 g3_2 200
Rph3_1 p3_1 p4_1 20
Rgh3_1 g3_1 g4_1 200
RD3_2 p3_2 d3_2 5k
M3_2 d3_2 g3_2 0 0 nm W=10u L=1u
Rpv3_2 p3_2 p3_3 20
Rgv3_2 g3_2 g3_3 200
Rph3_2 p3_2 p4_2 20
Rgh3_2 g3_2 g4_2 200
RD3_3 p3_3 d3_3 5k
M3_3 d3_3 g3_3 0 0 nm W=10u L=1u
Rpv3_3 p3_3 p3_4 20
Rgv3_3 g3_3 g3_4 200
Rph3_3 p3_3 p4_3 20
Rgh3_3 g3_3 g4_3 200
RD3_4 p3_4 d3_4 5k
M3_4 d3_4 g3_4 0 0 nm W=10u L=1u
Rpv3_4 p3_4 p3_5 20
Rgv3_4 g3_4 g3_5 200
Rph3_4 p3_4 p4_4 20
Rgh3_4 g3_4 g4_4 200
RD3_5 p3_5 d3_5 5k
M3_5 d3_5 g3_5 0 0 nm W=10u L=1u
Rpv3_5 p3_5 p3_6 20
Rgv3_5 g3_5 g3_6 200
Rph3_5 p3_5 p4_5 20
Rgh3_5 g3_5 g4_5 200
RD3_6 p3_6 d3_6 5k
M3_6 d3_6 g3_6 0 0 nm W=10u L=1u
Rpv3_6 p3_6 p3_7 20
Rgv3_6 g3_6 g3_7 200
Rph3_6 p3_6 p4_6 20
Rgh3_6 g3_6 g4_6 200
RD3_7 p3_7 d3_7 5k
M3_7 d3_7 g3_7 0 0 nm W=10u L=1u
Rpv3_7 p3_7 p3_8 20
Rgv3_7 g3_7 g3_8 200
Rph3_7 p3_7 p4_7 20
Rgh3_7 g3_7 g4_7 200
RD3_8 p3_8 d3_8 5k
M3_8 d3_8 g3_8 0 0 nm W=10u L=1u
Rpv3_8 p3_8 p3_9 20
Rgv3_8 g3_8 g3_9 200
Rph3_8 p3_8 p4_8 20
Rgh3_8 g3_8 g4_8 200
RD3_9 p3_9 d3_9 5k
M3_9 d3_9 g3_9 0 0 nm W=10u L=1u
Rpv3_9 p3_9 p3_10 20
Rgv3_9 g3_9 g3_10 200
Rph3_9 p3_9 p4_9 20
Rgh3_9 g3_9 g4_9 200
RD3_10 p3_10 d3_10 5k
M3_10 d3_10 g3_10 0 0 nm W=10u L=1u
Rpv3_10 p3_10 p3_11 20
Rgv3_10 g3_10 g3_11 200
Rph3_10 p3_10 p4_10 20
Rgh3_10 g3_10 g4_10 200
RD3_11 p3_11 d3_11 5k
M3_11 d3_11 g3_11 0 0 nm W=10u L=1u
Rpv3_11 p3_11 p3_12 20
Rgv3_11 g3_11 g3_12 200
Rph3_11 p3_11 p4_11 20
Rgh3_11 g3_11 g4_11 200
RD3_12 p3_12 d3_12 5k
M3_12 d3_12 g3_12 0 0 nm W=10u L=1u
Rpv3_12 p3_12 p3_13 20
Rgv3_12 g3_12 g3_13 200
Rph3_12 p3_12 p4_12 20
Rgh3_12 g3_12 g4_12 200
RD3_13 p3_13 d3_13 5k
M3_13 d3_13 g3_13 0 0 nm W=10u L=1u
Rpv3_13 p3_13 p3_14 20
Rgv3_13 g3_13 g3_14 200
Rph3_13 p3_13 p4_13 20
Rgh3_13 g3_13 g4_13 200
RD3_14 p3_14 d3_14 5k
M3_14 d3_14 g3_14 0 0 nm W=10u L=1u
Rpv3_14 p3_14 p3_15 20
Rgv3_14 g3_14 g3_15 200
Rph3_14 p3_14 p4_14 20
Rgh3_14 g3_14 g4_14 200
RD3_15 p3_15 d3_15 5k
M3_15 d3_15 g3_15 0 0 nm W=10u L=1u
Rpv3_15 p3_15 p3_16 20
Rgv3_15 g3_15 g3_16 200
Rph3_15 p3_15 p4_15 20
Rgh3_15 g3_15 g4_15 200
RD3_16 p3_16 d3_16 5k
M3_16 d3_16 g3_16 0 0 nm W=10u L=1u
Rpv3_16 p3_16 p3_17 20
Rgv3_16 g3_16 g3_17 200
Rph3_16 p3_16 p4_16 20
Rgh3_16 g3_16 g4_16 200
RD3_17 p3_17 d3_17 5k
M3_17 d3_17 g3_17 0 0 nm W=10u L=1u
Rpv3_17 p3_17 p3_18 20
Rgv3_17 g3_17 g3_18 200
Rph3_17 p3_17 p4_17 20
Rgh3_17 g3_17 g4_17 200
RD3_18 p3_18 d3_18 5k
M3_18 d3_18 g3_18 0 0 nm W=10u L=1u
Rpv3_18 p3_18 p3_19 20
Rgv3_18 g3_18 g3_19 200
Rph3_18 p3_18 p4_18 20
Rgh3_18 g3_18 g4_18 200
RD3_19 p3_19 d3_19 5k
M3_19 d3_19 g3_19 0 0 nm W=10u L=1u
Rph3_19 p3_19 p4_19 20
Rgh3_19 g3_19 g4_19 200
RD4_0 p4_0 d4_0 5k
M4_0 d4_0 g4_0 0 0 nm W=10u L=1u
Rpv4_0 p4_0 p4_1 20
Rgv4_0 g4_0 g4_1 200
Rph4_0 p4_0 p5_0 20
Rgh4_0 g4_0 g5_0 200
RD4_1 p4_1 d4_1 5k
M4_1 d4_1 g4_1 0 0 nm W=10u L=1u
Rpv4_1 p4_1 p4_2 20
Rgv4_1 g4_1 g4_2 200
Rph4_1 p4_1 p5_1 20
Rgh4_1 g4_1 g5_1 200
RD4_2 p4_2 d4_2 5k
M4_2 d4_2 g4_2 0 0 nm W=10u L=1u
Rpv4_2 p4_2 p4_3 20
Rgv4_2 g4_2 g4_3 200
Rph4_2 p4_2 p5_2 20
Rgh4_2 g4_2 g5_2 200
RD4_3 p4_3 d4_3 5k
M4_3 d4_3 g4_3 0 0 nm W=10u L=1u
Rpv4_3 p4_3 p4_4 20
Rgv4_3 g4_3 g4_4 200
Rph4_3 p4_3 p5_3 20
Rgh4_3 g4_3 g5_3 200
RD4_4 p4_4 d4_4 5k
M4_4 d4_4 g4_4 0 0 nm W=10u L=1u
Rpv4_4 p4_4 p4_5 20
Rgv4_4 g4_4 g4_5 200
Rph4_4 p4_4 p5_4 20
Rgh4_4 g4_4 g5_4 200
RD4_5 p4_5 d4_5 5k
M4_5 d4_5 g4_5 0 0 nm W=10u L=1u
Rpv4_5 p4_5 p4_6 20
Rgv4_5 g4_5 g4_6 200
Rph4_5 p4_5 p5_5 20
Rgh4_5 g4_5 g5_5 200
RD4_6 p4_6 d4_6 5k
M4_6 d4_6 g4_6 0 0 nm W=10u L=1u
Rpv4_6 p4_6 p4_7 20
Rgv4_6 g4_6 g4_7 200
Rph4_6 p4_6 p5_6 20
Rgh4_6 g4_6 g5_6 200
RD4_7 p4_7 d4_7 5k
M4_7 d4_7 g4_7 0 0 nm W=10u L=1u
Rpv4_7 p4_7 p4_8 20
Rgv4_7 g4_7 g4_8 200
Rph4_7 p4_7 p5_7 20
Rgh4_7 g4_7 g5_7 200
RD4_8 p4_8 d4_8 5k
M4_8 d4_8 g4_8 0 0 nm W=10u L=1u
Rpv4_8 p4_8 p4_9 20
Rgv4_8 g4_8 g4_9 200
Rph4_8 p4_8 p5_8 20
Rgh4_8 g4_8 g5_8 200
RD4_9 p4_9 d4_9 5k
M4_9 d4_9 g4_9 0 0 nm W=10u L=1u
Rpv4_9 p4_9 p4_10 20
Rgv4_9 g4_9 g4_10 200
Rph4_9 p4_9 p5_9 20
Rgh4_9 g4_9 g5_9 200
RD4_10 p4_10 d4_10 5k
M4_10 d4_10 g4_10 0 0 nm W=10u L=1u
Rpv4_10 p4_10 p4_11 20
Rgv4_10 g4_10 g4_11 200
Rph4_10 p4_10 p5_10 20
Rgh4_10 g4_10 g5_10 200
RD4_11 p4_11 d4_11 5k
M4_11 d4_11 g4_11 0 0 nm W=10u L=1u
Rpv4_11 p4_11 p4_12 20
Rgv4_11 g4_11 g4_12 200
Rph4_11 p4_11 p5_11 20
Rgh4_11 g4_11 g5_11 200
RD4_12 p4_12 d4_12 5k
M4_12 d4_12 g4_12 0 0 nm W=10u L=1u
Rpv4_12 p4_12 p4_13 20
Rgv4_12 g4_12 g4_13 200
Rph4_12 p4_12 p5_12 20
Rgh4_12 g4_12 g5_12 200
RD4_13 p4_13 d4_13 5k
M4_13 d4_13 g4_13 0 0 nm W=10u L=1u
Rpv4_13 p4_13 p4_14 20
Rgv4_13 g4_13 g4_14 200
Rph4_13 p4_13 p5_13 20
Rgh4_13 g4_13 g5_13 200
RD4_14 p4_14 d4_14 5k
M4_14 d4_14 g4_14 0 0 nm W=10u L=1u
Rpv4_14 p4_14 p4_15 20
Rgv4_14 g4_14 g4_15 200
Rph4_14 p4_14 p5_14 20
Rgh4_14 g4_14 g5_14 200
RD4_15 p4_15 d4_15 5k
M4_15 d4_15 g4_15 0 0 nm W=10u L=1u
Rpv4_15 p4_15 p4_16 20
Rgv4_15 g4_15 g4_16 200
Rph4_15 p4_15 p5_15 20
Rgh4_15 g4_15 g5_15 200
RD4_16 p4_16 d4_16 5k
M4_16 d4_16 g4_16 0 0 nm W=10u L=1u
Rpv4_16 p4_16 p4_17 20
Rgv4_16 g4_16 g4_17 200
Rph4_16 p4_16 p5_16 20
Rgh4_16 g4_16 g5_16 200
RD4_17 p4_17 d4_17 5k
M4_17 d4_17 g4_17 0 0 nm W=10u L=1u
Rpv4_17 p4_17 p4_18 20
Rgv4_17 g4_17 g4_18 200
Rph4_17 p4_17 p5_17 20
Rgh4_17 g4_17 g5_17 200
RD4_18 p4_18 d4_18 5k
M4_18 d4_18 g4_18 0 0 nm W=10u L=1u
Rpv4_18 p4_18 p4_19 20
Rgv4_18 g4_18 g4_19 200
Rph4_18 p4_18 p5_18 20
Rgh4_18 g4_18 g5_18 200
RD4_19 p4_19 d4_19 5k
M4_19 d4_19 g4_19 0 0 nm W=10u L=1u
Rph4_19 p4_19 p5_19 20
Rgh4_19 g4_19 g5_19 200
RD5_0 p5_0 d5_0 5k
M5_0 d5_0 g5_0 0 0 nm W=10u L=1u
Rpv5_0 p5_0 p5_1 20
Rgv5_0 g5_0 g5_1 200
Rph5_0 p5_0 p6_0 20
Rgh5_0 g5_0 g6_0 200
RD5_1 p5_1 d5_1 5k
M5_1 d5_1 g5_1 0 0 nm W=10u L=1u
Rpv5_1 p5_1 p5_2 20
Rgv5_1 g5_1 g5_2 200
Rph5_1 p5_1 p6_1 20
Rgh5_1 g5_1 g6_1 200
RD5_2 p5_2 d5_2 5k
M5_2 d5_2 g5_2 0 0 nm W=10u L=1u
Rpv5_2 p5_2 p5_3 20
Rgv5_2 g5_2 g5_3 200
Rph5_2 p5_2 p6_2 20
Rgh5_2 g5_2 g6_2 200
RD5_3 p5_3 d5_3 5k
M5_3 d5_3 g5_3 0 0 nm W=10u L=1u
Rpv5_3 p5_3 p5_4 20
Rgv5_3 g5_3 g5_4 200
Rph5_3 p5_3 p6_3 20
Rgh5_3 g5_3 g6_3 200
RD5_4 p5_4 d5_4 5k
M5_4 d5_4 g5_4 0 0 nm W=10u L=1u
Rpv5_4 p5_4 p5_5 20
Rgv5_4 g5_4 g5_5 200
Rph5_4 p5_4 p6_4 20
Rgh5_4 g5_4 g6_4 200
RD5_5 p5_5 d5_5 5k
M5_5 d5_5 g5_5 0 0 nm W=10u L=1u
Rpv5_5 p5_5 p5_6 20
Rgv5_5 g5_5 g5_6 200
Rph5_5 p5_5 p6_5 20
Rgh5_5 g5_5 g6_5 200
RD5_6 p5_6 d5_6 5k
M5_6 d5_6 g5_6 0 0 nm W=10u L=1u
Rpv5_6 p5_6 p5_7 20
Rgv5_6 g5_6 g5_7 200
Rph5_6 p5_6 p6_6 20
Rgh5_6 g5_6 g6_6 200
RD5_7 p5_7 d5_7 5k
M5_7 d5_7 g5_7 0 0 nm W=10u L=1u
Rpv5_7 p5_7 p5_8 20
Rgv5_7 g5_7 g5_8 200
Rph5_7 p5_7 p6_7 20
Rgh5_7 g5_7 g6_7 200
RD5_8 p5_8 d5_8 5k
M5_8 d5_8 g5_8 0 0 nm W=10u L=1u
Rpv5_8 p5_8 p5_9 20
Rgv5_8 g5_8 g5_9 200
Rph5_8 p5_8 p6_8 20
Rgh5_8 g5_8 g6_8 200
RD5_9 p5_9 d5_9 5k
M5_9 d5_9 g5_9 0 0 nm W=10u L=1u
Rpv5_9 p5_9 p5_10 20
Rgv5_9 g5_9 g5_10 200
Rph5_9 p5_9 p6_9 20
Rgh5_9 g5_9 g6_9 200
RD5_10 p5_10 d5_10 5k
M5_10 d5_10 g5_10 0 0 nm W=10u L=1u
Rpv5_10 p5_10 p5_11 20
Rgv5_10 g5_10 g5_11 200
Rph5_10 p5_10 p6_10 20
Rgh5_10 g5_10 g6_10 200
RD5_11 p5_11 d5_11 5k
M5_11 d5_11 g5_11 0 0 nm W=10u L=1u
Rpv5_11 p5_11 p5_12 20
Rgv5_11 g5_11 g5_12 200
Rph5_11 p5_11 p6_11 20
Rgh5_11 g5_11 g6_11 200
RD5_12 p5_12 d5_12 5k
M5_12 d5_12 g5_12 0 0 nm W=10u L=1u
Rpv5_12 p5_12 p5_13 20
Rgv5_12 g5_12 g5_13 200
Rph5_12 p5_12 p6_12 20
Rgh5_12 g5_12 g6_12 200
RD5_13 p5_13 d5_13 5k
M5_13 d5_13 g5_13 0 0 nm W=10u L=1u
Rpv5_13 p5_13 p5_14 20
Rgv5_13 g5_13 g5_14 200
Rph5_13 p5_13 p6_13 20
Rgh5_13 g5_13 g6_13 200
RD5_14 p5_14 d5_14 5k
M5_14 d5_14 g5_14 0 0 nm W=10u L=1u
Rpv5_14 p5_14 p5_15 20
Rgv5_14 g5_14 g5_15 200
Rph5_14 p5_14 p6_14 20
Rgh5_14 g5_14 g6_14 200
RD5_15 p5_15 d5_15 5k
M5_15 d5_15 g5_15 0 0 nm W=10u L=1u
Rpv5_15 p5_15 p5_16 20
Rgv5_15 g5_15 g5_16 200
Rph5_15 p5_15 p6_15 20
Rgh5_15 g5_15 g6_15 200
RD5_16 p5_16 d5_16 5k
M5_16 d5_16 g5_16 0 0 nm W=10u L=1u
Rpv5_16 p5_16 p5_17 20
Rgv5_16 g5_16 g5_17 200
Rph5_16 p5_16 p6_16 20
Rgh5_16 g5_16 g6_16 200
RD5_17 p5_17 d5_17 5k
M5_17 d5_17 g5_17 0 0 nm W=10u L=1u
Rpv5_17 p5_17 p5_18 20
Rgv5_17 g5_17 g5_18 200
Rph5_17 p5_17 p6_17 20
Rgh5_17 g5_17 g6_17 200
RD5_18 p5_18 d5_18 5k
M5_18 d5_18 g5_18 0 0 nm W=10u L=1u
Rpv5_18 p5_18 p5_19 20
Rgv5_18 g5_18 g5_19 200
Rph5_18 p5_18 p6_18 20
Rgh5_18 g5_18 g6_18 200
RD5_19 p5_19 d5_19 5k
M5_19 d5_19 g5_19 0 0 nm W=10u L=1u
Rph5_19 p5_19 p6_19 20
Rgh5_19 g5_19 g6_19 200
RD6_0 p6_0 d6_0 5k
M6_0 d6_0 g6_0 0 0 nm W=10u L=1u
Rpv6_0 p6_0 p6_1 20
Rgv6_0 g6_0 g6_1 200
Rph6_0 p6_0 p7_0 20
Rgh6_0 g6_0 g7_0 200
RD6_1 p6_1 d6_1 5k
M6_1 d6_1 g6_1 0 0 nm W=10u L=1u
Rpv6_1 p6_1 p6_2 20
Rgv6_1 g6_1 g6_2 200
Rph6_1 p6_1 p7_1 20
Rgh6_1 g6_1 g7_1 200
RD6_2 p6_2 d6_2 5k
M6_2 d6_2 g6_2 0 0 nm W=10u L=1u
Rpv6_2 p6_2 p6_3 20
Rgv6_2 g6_2 g6_3 200
Rph6_2 p6_2 p7_2 20
Rgh6_2 g6_2 g7_2 200
RD6_3 p6_3 d6_3 5k
M6_3 d6_3 g6_3 0 0 nm W=10u L=1u
Rpv6_3 p6_3 p6_4 20
Rgv6_3 g6_3 g6_4 200
Rph6_3 p6_3 p7_3 20
Rgh6_3 g6_3 g7_3 200
RD6_4 p6_4 d6_4 5k
M6_4 d6_4 g6_4 0 0 nm W=10u L=1u
Rpv6_4 p6_4 p6_5 20
Rgv6_4 g6_4 g6_5 200
Rph6_4 p6_4 p7_4 20
Rgh6_4 g6_4 g7_4 200
RD6_5 p6_5 d6_5 5k
M6_5 d6_5 g6_5 0 0 nm W=10u L=1u
Rpv6_5 p6_5 p6_6 20
Rgv6_5 g6_5 g6_6 200
Rph6_5 p6_5 p7_5 20
Rgh6_5 g6_5 g7_5 200
RD6_6 p6_6 d6_6 5k
M6_6 d6_6 g6_6 0 0 nm W=10u L=1u
Rpv6_6 p6_6 p6_7 20
Rgv6_6 g6_6 g6_7 200
Rph6_6 p6_6 p7_6 20
Rgh6_6 g6_6 g7_6 200
RD6_7 p6_7 d6_7 5k
M6_7 d6_7 g6_7 0 0 nm W=10u L=1u
Rpv6_7 p6_7 p6_8 20
Rgv6_7 g6_7 g6_8 200
Rph6_7 p6_7 p7_7 20
Rgh6_7 g6_7 g7_7 200
RD6_8 p6_8 d6_8 5k
M6_8 d6_8 g6_8 0 0 nm W=10u L=1u
Rpv6_8 p6_8 p6_9 20
Rgv6_8 g6_8 g6_9 200
Rph6_8 p6_8 p7_8 20
Rgh6_8 g6_8 g7_8 200
RD6_9 p6_9 d6_9 5k
M6_9 d6_9 g6_9 0 0 nm W=10u L=1u
Rpv6_9 p6_9 p6_10 20
Rgv6_9 g6_9 g6_10 200
Rph6_9 p6_9 p7_9 20
Rgh6_9 g6_9 g7_9 200
RD6_10 p6_10 d6_10 5k
M6_10 d6_10 g6_10 0 0 nm W=10u L=1u
Rpv6_10 p6_10 p6_11 20
Rgv6_10 g6_10 g6_11 200
Rph6_10 p6_10 p7_10 20
Rgh6_10 g6_10 g7_10 200
RD6_11 p6_11 d6_11 5k
M6_11 d6_11 g6_11 0 0 nm W=10u L=1u
Rpv6_11 p6_11 p6_12 20
Rgv6_11 g6_11 g6_12 200
Rph6_11 p6_11 p7_11 20
Rgh6_11 g6_11 g7_11 200
RD6_12 p6_12 d6_12 5k
M6_12 d6_12 g6_12 0 0 nm W=10u L=1u
Rpv6_12 p6_12 p6_13 20
Rgv6_12 g6_12 g6_13 200
Rph6_12 p6_12 p7_12 20
Rgh6_12 g6_12 g7_12 200
RD6_13 p6_13 d6_13 5k
M6_13 d6_13 g6_13 0 0 nm W=10u L=1u
Rpv6_13 p6_13 p6_14 20
Rgv6_13 g6_13 g6_14 200
Rph6_13 p6_13 p7_13 20
Rgh6_13 g6_13 g7_13 200
RD6_14 p6_14 d6_14 5k
M6_14 d6_14 g6_14 0 0 nm W=10u L=1u
Rpv6_14 p6_14 p6_15 20
Rgv6_14 g6_14 g6_15 200
Rph6_14 p6_14 p7_14 20
Rgh6_14 g6_14 g7_14 200
RD6_15 p6_15 d6_15 5k
M6_15 d6_15 g6_15 0 0 nm W=10u L=1u
Rpv6_15 p6_15 p6_16 20
Rgv6_15 g6_15 g6_16 200
Rph6_15 p6_15 p7_15 20
Rgh6_15 g6_15 g7_15 200
RD6_16 p6_16 d6_16 5k
M6_16 d6_16 g6_16 0 0 nm W=10u L=1u
Rpv6_16 p6_16 p6_17 20
Rgv6_16 g6_16 g6_17 200
Rph6_16 p6_16 p7_16 20
Rgh6_16 g6_16 g7_16 200
RD6_17 p6_17 d6_17 5k
M6_17 d6_17 g6_17 0 0 nm W=10u L=1u
Rpv6_17 p6_17 p6_18 20
Rgv6_17 g6_17 g6_18 200
Rph6_17 p6_17 p7_17 20
Rgh6_17 g6_17 g7_17 200
RD6_18 p6_18 d6_18 5k
M6_18 d6_18 g6_18 0 0 nm W=10u L=1u
Rpv6_18 p6_18 p6_19 20
Rgv6_18 g6_18 g6_19 200
Rph6_18 p6_18 p7_18 20
Rgh6_18 g6_18 g7_18 200
RD6_19 p6_19 d6_19 5k
M6_19 d6_19 g6_19 0 0 nm W=10u L=1u
Rph6_19 p6_19 p7_19 20
Rgh6_19 g6_19 g7_19 200
RD7_0 p7_0 d7_0 5k
M7_0 d7_0 g7_0 0 0 nm W=10u L=1u
Rpv7_0 p7_0 p7_1 20
Rgv7_0 g7_0 g7_1 200
Rph7_0 p7_0 p8_0 20
Rgh7_0 g7_0 g8_0 200
RD7_1 p7_1 d7_1 5k
M7_1 d7_1 g7_1 0 0 nm W=10u L=1u
Rpv7_1 p7_1 p7_2 20
Rgv7_1 g7_1 g7_2 200
Rph7_1 p7_1 p8_1 20
Rgh7_1 g7_1 g8_1 200
RD7_2 p7_2 d7_2 5k
M7_2 d7_2 g7_2 0 0 nm W=10u L=1u
Rpv7_2 p7_2 p7_3 20
Rgv7_2 g7_2 g7_3 200
Rph7_2 p7_2 p8_2 20
Rgh7_2 g7_2 g8_2 200
RD7_3 p7_3 d7_3 5k
M7_3 d7_3 g7_3 0 0 nm W=10u L=1u
Rpv7_3 p7_3 p7_4 20
Rgv7_3 g7_3 g7_4 200
Rph7_3 p7_3 p8_3 20
Rgh7_3 g7_3 g8_3 200
RD7_4 p7_4 d7_4 5k
M7_4 d7_4 g7_4 0 0 nm W=10u L=1u
Rpv7_4 p7_4 p7_5 20
Rgv7_4 g7_4 g7_5 200
Rph7_4 p7_4 p8_4 20
Rgh7_4 g7_4 g8_4 200
RD7_5 p7_5 d7_5 5k
M7_5 d7_5 g7_5 0 0 nm W=10u L=1u
Rpv7_5 p7_5 p7_6 20
Rgv7_5 g7_5 g7_6 200
Rph7_5 p7_5 p8_5 20
Rgh7_5 g7_5 g8_5 200
RD7_6 p7_6 d7_6 5k
M7_6 d7_6 g7_6 0 0 nm W=10u L=1u
Rpv7_6 p7_6 p7_7 20
Rgv7_6 g7_6 g7_7 200
Rph7_6 p7_6 p8_6 20
Rgh7_6 g7_6 g8_6 200
RD7_7 p7_7 d7_7 5k
M7_7 d7_7 g7_7 0 0 nm W=10u L=1u
Rpv7_7 p7_7 p7_8 20
Rgv7_7 g7_7 g7_8 200
Rph7_7 p7_7 p8_7 20
Rgh7_7 g7_7 g8_7 200
RD7_8 p7_8 d7_8 5k
M7_8 d7_8 g7_8 0 0 nm W=10u L=1u
Rpv7_8 p7_8 p7_9 20
Rgv7_8 g7_8 g7_9 200
Rph7_8 p7_8 p8_8 20
Rgh7_8 g7_8 g8_8 200
RD7_9 p7_9 d7_9 5k
M7_9 d7_9 g7_9 0 0 nm W=10u L=1u
Rpv7_9 p7_9 p7_10 20
Rgv7_9 g7_9 g7_10 200
Rph7_9 p7_9 p8_9 20
Rgh7_9 g7_9 g8_9 200
RD7_10 p7_10 d7_10 5k
M7_10 d7_10 g7_10 0 0 nm W=10u L=1u
Rpv7_10 p7_10 p7_11 20
Rgv7_10 g7_10 g7_11 200
Rph7_10 p7_10 p8_10 20
Rgh7_10 g7_10 g8_10 200
RD7_11 p7_11 d7_11 5k
M7_11 d7_11 g7_11 0 0 nm W=10u L=1u
Rpv7_11 p7_11 p7_12 20
Rgv7_11 g7_11 g7_12 200
Rph7_11 p7_11 p8_11 20
Rgh7_11 g7_11 g8_11 200
RD7_12 p7_12 d7_12 5k
M7_12 d7_12 g7_12 0 0 nm W=10u L=1u
Rpv7_12 p7_12 p7_13 20
Rgv7_12 g7_12 g7_13 200
Rph7_12 p7_12 p8_12 20
Rgh7_12 g7_12 g8_12 200
RD7_13 p7_13 d7_13 5k
M7_13 d7_13 g7_13 0 0 nm W=10u L=1u
Rpv7_13 p7_13 p7_14 20
Rgv7_13 g7_13 g7_14 200
Rph7_13 p7_13 p8_13 20
Rgh7_13 g7_13 g8_13 200
RD7_14 p7_14 d7_14 5k
M7_14 d7_14 g7_14 0 0 nm W=10u L=1u
Rpv7_14 p7_14 p7_15 20
Rgv7_14 g7_14 g7_15 200
Rph7_14 p7_14 p8_14 20
Rgh7_14 g7_14 g8_14 200
RD7_15 p7_15 d7_15 5k
M7_15 d7_15 g7_15 0 0 nm W=10u L=1u
Rpv7_15 p7_15 p7_16 20
Rgv7_15 g7_15 g7_16 200
Rph7_15 p7_15 p8_15 20
Rgh7_15 g7_15 g8_15 200
RD7_16 p7_16 d7_16 5k
M7_16 d7_16 g7_16 0 0 nm W=10u L=1u
Rpv7_16 p7_16 p7_17 20
Rgv7_16 g7_16 g7_17 200
Rph7_16 p7_16 p8_16 20
Rgh7_16 g7_16 g8_16 200
RD7_17 p7_17 d7_17 5k
M7_17 d7_17 g7_17 0 0 nm W=10u L=1u
Rpv7_17 p7_17 p7_18 20
Rgv7_17 g7_17 g7_18 200
Rph7_17 p7_17 p8_17 20
Rgh7_17 g7_17 g8_17 200
RD7_18 p7_18 d7_18 5k
M7_18 d7_18 g7_18 0 0 nm W=10u L=1u
Rpv7_18 p7_18 p7_19 20
Rgv7_18 g7_18 g7_19 200
Rph7_18 p7_18 p8_18 20
Rgh7_18 g7_18 g8_18 200
RD7_19 p7_19 d7_19 5k
M7_19 d7_19 g7_19 0 0 nm W=10u L=1u
Rph7_19 p7_19 p8_19 20
Rgh7_19 g7_19 g8_19 200
RD8_0 p8_0 d8_0 5k
M8_0 d8_0 g8_0 0 0 nm W=10u L=1u
Rpv8_0 p8_0 p8_1 20
Rgv8_0 g8_0 g8_1 200
Rph8_0 p8_0 p9_0 20
Rgh8_0 g8_0 g9_0 200
RD8_1 p8_1 d8_1 5k
M8_1 d8_1 g8_1 0 0 nm W=10u L=1u
Rpv8_1 p8_1 p8_2 20
Rgv8_1 g8_1 g8_2 200
Rph8_1 p8_1 p9_1 20
Rgh8_1 g8_1 g9_1 200
RD8_2 p8_2 d8_2 5k
M8_2 d8_2 g8_2 0 0 nm W=10u L=1u
Rpv8_2 p8_2 p8_3 20
Rgv8_2 g8_2 g8_3 200
Rph8_2 p8_2 p9_2 20
Rgh8_2 g8_2 g9_2 200
RD8_3 p8_3 d8_3 5k
M8_3 d8_3 g8_3 0 0 nm W=10u L=1u
Rpv8_3 p8_3 p8_4 20
Rgv8_3 g8_3 g8_4 200
Rph8_3 p8_3 p9_3 20
Rgh8_3 g8_3 g9_3 200
RD8_4 p8_4 d8_4 5k
M8_4 d8_4 g8_4 0 0 nm W=10u L=1u
Rpv8_4 p8_4 p8_5 20
Rgv8_4 g8_4 g8_5 200
Rph8_4 p8_4 p9_4 20
Rgh8_4 g8_4 g9_4 200
RD8_5 p8_5 d8_5 5k
M8_5 d8_5 g8_5 0 0 nm W=10u L=1u
Rpv8_5 p8_5 p8_6 20
Rgv8_5 g8_5 g8_6 200
Rph8_5 p8_5 p9_5 20
Rgh8_5 g8_5 g9_5 200
RD8_6 p8_6 d8_6 5k
M8_6 d8_6 g8_6 0 0 nm W=10u L=1u
Rpv8_6 p8_6 p8_7 20
Rgv8_6 g8_6 g8_7 200
Rph8_6 p8_6 p9_6 20
Rgh8_6 g8_6 g9_6 200
RD8_7 p8_7 d8_7 5k
M8_7 d8_7 g8_7 0 0 nm W=10u L=1u
Rpv8_7 p8_7 p8_8 20
Rgv8_7 g8_7 g8_8 200
Rph8_7 p8_7 p9_7 20
Rgh8_7 g8_7 g9_7 200
RD8_8 p8_8 d8_8 5k
M8_8 d8_8 g8_8 0 0 nm W=10u L=1u
Rpv8_8 p8_8 p8_9 20
Rgv8_8 g8_8 g8_9 200
Rph8_8 p8_8 p9_8 20
Rgh8_8 g8_8 g9_8 200
RD8_9 p8_9 d8_9 5k
M8_9 d8_9 g8_9 0 0 nm W=10u L=1u
Rpv8_9 p8_9 p8_10 20
Rgv8_9 g8_9 g8_10 200
Rph8_9 p8_9 p9_9 20
Rgh8_9 g8_9 g9_9 200
RD8_10 p8_10 d8_10 5k
M8_10 d8_10 g8_10 0 0 nm W=10u L=1u
Rpv8_10 p8_10 p8_11 20
Rgv8_10 g8_10 g8_11 200
Rph8_10 p8_10 p9_10 20
Rgh8_10 g8_10 g9_10 200
RD8_11 p8_11 d8_11 5k
M8_11 d8_11 g8_11 0 0 nm W=10u L=1u
Rpv8_11 p8_11 p8_12 20
Rgv8_11 g8_11 g8_12 200
Rph8_11 p8_11 p9_11 20
Rgh8_11 g8_11 g9_11 200
RD8_12 p8_12 d8_12 5k
M8_12 d8_12 g8_12 0 0 nm W=10u L=1u
Rpv8_12 p8_12 p8_13 20
Rgv8_12 g8_12 g8_13 200
Rph8_12 p8_12 p9_12 20
Rgh8_12 g8_12 g9_12 200
RD8_13 p8_13 d8_13 5k
M8_13 d8_13 g8_13 0 0 nm W=10u L=1u
Rpv8_13 p8_13 p8_14 20
Rgv8_13 g8_13 g8_14 200
Rph8_13 p8_13 p9_13 20
Rgh8_13 g8_13 g9_13 200
RD8_14 p8_14 d8_14 5k
M8_14 d8_14 g8_14 0 0 nm W=10u L=1u
Rpv8_14 p8_14 p8_15 20
Rgv8_14 g8_14 g8_15 200
Rph8_14 p8_14 p9_14 20
Rgh8_14 g8_14 g9_14 200
RD8_15 p8_15 d8_15 5k
M8_15 d8_15 g8_15 0 0 nm W=10u L=1u
Rpv8_15 p8_15 p8_16 20
Rgv8_15 g8_15 g8_16 200
Rph8_15 p8_15 p9_15 20
Rgh8_15 g8_15 g9_15 200
RD8_16 p8_16 d8_16 5k
M8_16 d8_16 g8_16 0 0 nm W=10u L=1u
Rpv8_16 p8_16 p8_17 20
Rgv8_16 g8_16 g8_17 200
Rph8_16 p8_16 p9_16 20
Rgh8_16 g8_16 g9_16 200
RD8_17 p8_17 d8_17 5k
M8_17 d8_17 g8_17 0 0 nm W=10u L=1u
Rpv8_17 p8_17 p8_18 20
Rgv8_17 g8_17 g8_18 200
Rph8_17 p8_17 p9_17 20
Rgh8_17 g8_17 g9_17 200
RD8_18 p8_18 d8_18 5k
M8_18 d8_18 g8_18 0 0 nm W=10u L=1u
Rpv8_18 p8_18 p8_19 20
Rgv8_18 g8_18 g8_19 200
Rph8_18 p8_18 p9_18 20
Rgh8_18 g8_18 g9_18 200
RD8_19 p8_19 d8_19 5k
M8_19 d8_19 g8_19 0 0 nm W=10u L=1u
Rph8_19 p8_19 p9_19 20
Rgh8_19 g8_19 g9_19 200
RD9_0 p9_0 d9_0 5k
M9_0 d9_0 g9_0 0 0 nm W=10u L=1u
Rpv9_0 p9_0 p9_1 20
Rgv9_0 g9_0 g9_1 200
Rph9_0 p9_0 p10_0 20
Rgh9_0 g9_0 g10_0 200
RD9_1 p9_1 d9_1 5k
M9_1 d9_1 g9_1 0 0 nm W=10u L=1u
Rpv9_1 p9_1 p9_2 20
Rgv9_1 g9_1 g9_2 200
Rph9_1 p9_1 p10_1 20
Rgh9_1 g9_1 g10_1 200
RD9_2 p9_2 d9_2 5k
M9_2 d9_2 g9_2 0 0 nm W=10u L=1u
Rpv9_2 p9_2 p9_3 20
Rgv9_2 g9_2 g9_3 200
Rph9_2 p9_2 p10_2 20
Rgh9_2 g9_2 g10_2 200
RD9_3 p9_3 d9_3 5k
M9_3 d9_3 g9_3 0 0 nm W=10u L=1u
Rpv9_3 p9_3 p9_4 20
Rgv9_3 g9_3 g9_4 200
Rph9_3 p9_3 p10_3 20
Rgh9_3 g9_3 g10_3 200
RD9_4 p9_4 d9_4 5k
M9_4 d9_4 g9_4 0 0 nm W=10u L=1u
Rpv9_4 p9_4 p9_5 20
Rgv9_4 g9_4 g9_5 200
Rph9_4 p9_4 p10_4 20
Rgh9_4 g9_4 g10_4 200
RD9_5 p9_5 d9_5 5k
M9_5 d9_5 g9_5 0 0 nm W=10u L=1u
Rpv9_5 p9_5 p9_6 20
Rgv9_5 g9_5 g9_6 200
Rph9_5 p9_5 p10_5 20
Rgh9_5 g9_5 g10_5 200
RD9_6 p9_6 d9_6 5k
M9_6 d9_6 g9_6 0 0 nm W=10u L=1u
Rpv9_6 p9_6 p9_7 20
Rgv9_6 g9_6 g9_7 200
Rph9_6 p9_6 p10_6 20
Rgh9_6 g9_6 g10_6 200
RD9_7 p9_7 d9_7 5k
M9_7 d9_7 g9_7 0 0 nm W=10u L=1u
Rpv9_7 p9_7 p9_8 20
Rgv9_7 g9_7 g9_8 200
Rph9_7 p9_7 p10_7 20
Rgh9_7 g9_7 g10_7 200
RD9_8 p9_8 d9_8 5k
M9_8 d9_8 g9_8 0 0 nm W=10u L=1u
Rpv9_8 p9_8 p9_9 20
Rgv9_8 g9_8 g9_9 200
Rph9_8 p9_8 p10_8 20
Rgh9_8 g9_8 g10_8 200
RD9_9 p9_9 d9_9 5k
M9_9 d9_9 g9_9 0 0 nm W=10u L=1u
Rpv9_9 p9_9 p9_10 20
Rgv9_9 g9_9 g9_10 200
Rph9_9 p9_9 p10_9 20
Rgh9_9 g9_9 g10_9 200
RD9_10 p9_10 d9_10 5k
M9_10 d9_10 g9_10 0 0 nm W=10u L=1u
Rpv9_10 p9_10 p9_11 20
Rgv9_10 g9_10 g9_11 200
Rph9_10 p9_10 p10_10 20
Rgh9_10 g9_10 g10_10 200
RD9_11 p9_11 d9_11 5k
M9_11 d9_11 g9_11 0 0 nm W=10u L=1u
Rpv9_11 p9_11 p9_12 20
Rgv9_11 g9_11 g9_12 200
Rph9_11 p9_11 p10_11 20
Rgh9_11 g9_11 g10_11 200
RD9_12 p9_12 d9_12 5k
M9_12 d9_12 g9_12 0 0 nm W=10u L=1u
Rpv9_12 p9_12 p9_13 20
Rgv9_12 g9_12 g9_13 200
Rph9_12 p9_12 p10_12 20
Rgh9_12 g9_12 g10_12 200
RD9_13 p9_13 d9_13 5k
M9_13 d9_13 g9_13 0 0 nm W=10u L=1u
Rpv9_13 p9_13 p9_14 20
Rgv9_13 g9_13 g9_14 200
Rph9_13 p9_13 p10_13 20
Rgh9_13 g9_13 g10_13 200
RD9_14 p9_14 d9_14 5k
M9_14 d9_14 g9_14 0 0 nm W=10u L=1u
Rpv9_14 p9_14 p9_15 20
Rgv9_14 g9_14 g9_15 200
Rph9_14 p9_14 p10_14 20
Rgh9_14 g9_14 g10_14 200
RD9_15 p9_15 d9_15 5k
M9_15 d9_15 g9_15 0 0 nm W=10u L=1u
Rpv9_15 p9_15 p9_16 20
Rgv9_15 g9_15 g9_16 200
Rph9_15 p9_15 p10_15 20
Rgh9_15 g9_15 g10_15 200
RD9_16 p9_16 d9_16 5k
M9_16 d9_16 g9_16 0 0 nm W=10u L=1u
Rpv9_16 p9_16 p9_17 20
Rgv9_16 g9_16 g9_17 200
Rph9_16 p9_16 p10_16 20
Rgh9_16 g9_16 g10_16 200
RD9_17 p9_17 d9_17 5k
M9_17 d9_17 g9_17 0 0 nm W=10u L=1u
Rpv9_17 p9_17 p9_18 20
Rgv9_17 g9_17 g9_18 200
Rph9_17 p9_17 p10_17 20
Rgh9_17 g9_17 g10_17 200
RD9_18 p9_18 d9_18 5k
M9_18 d9_18 g9_18 0 0 nm W=10u L=1u
Rpv9_18 p9_18 p9_19 20
Rgv9_18 g9_18 g9_19 200
Rph9_18 p9_18 p10_18 20
Rgh9_18 g9_18 g10_18 200
RD9_19 p9_19 d9_19 5k
M9_19 d9_19 g9_19 0 0 nm W=10u L=1u
Rph9_19 p9_19 p10_19 20
Rgh9_19 g9_19 g10_19 200
RD10_0 p10_0 d10_0 5k
M10_0 d10_0 g10_0 0 0 nm W=10u L=1u
Rpv10_0 p10_0 p10_1 20
Rgv10_0 g10_0 g10_1 200
Rph10_0 p10_0 p11_0 20
Rgh10_0 g10_0 g11_0 200
RD10_1 p10_1 d10_1 5k
M10_1 d10_1 g10_1 0 0 nm W=10u L=1u
Rpv10_1 p10_1 p10_2 20
Rgv10_1 g10_1 g10_2 200
Rph10_1 p10_1 p11_1 20
Rgh10_1 g10_1 g11_1 200
RD10_2 p10_2 d10_2 5k
M10_2 d10_2 g10_2 0 0 nm W=10u L=1u
Rpv10_2 p10_2 p10_3 20
Rgv10_2 g10_2 g10_3 200
Rph10_2 p10_2 p11_2 20
Rgh10_2 g10_2 g11_2 200
RD10_3 p10_3 d10_3 5k
M10_3 d10_3 g10_3 0 0 nm W=10u L=1u
Rpv10_3 p10_3 p10_4 20
Rgv10_3 g10_3 g10_4 200
Rph10_3 p10_3 p11_3 20
Rgh10_3 g10_3 g11_3 200
RD10_4 p10_4 d10_4 5k
M10_4 d10_4 g10_4 0 0 nm W=10u L=1u
Rpv10_4 p10_4 p10_5 20
Rgv10_4 g10_4 g10_5 200
Rph10_4 p10_4 p11_4 20
Rgh10_4 g10_4 g11_4 200
RD10_5 p10_5 d10_5 5k
M10_5 d10_5 g10_5 0 0 nm W=10u L=1u
Rpv10_5 p10_5 p10_6 20
Rgv10_5 g10_5 g10_6 200
Rph10_5 p10_5 p11_5 20
Rgh10_5 g10_5 g11_5 200
RD10_6 p10_6 d10_6 5k
M10_6 d10_6 g10_6 0 0 nm W=10u L=1u
Rpv10_6 p10_6 p10_7 20
Rgv10_6 g10_6 g10_7 200
Rph10_6 p10_6 p11_6 20
Rgh10_6 g10_6 g11_6 200
RD10_7 p10_7 d10_7 5k
M10_7 d10_7 g10_7 0 0 nm W=10u L=1u
Rpv10_7 p10_7 p10_8 20
Rgv10_7 g10_7 g10_8 200
Rph10_7 p10_7 p11_7 20
Rgh10_7 g10_7 g11_7 200
RD10_8 p10_8 d10_8 5k
M10_8 d10_8 g10_8 0 0 nm W=10u L=1u
Rpv10_8 p10_8 p10_9 20
Rgv10_8 g10_8 g10_9 200
Rph10_8 p10_8 p11_8 20
Rgh10_8 g10_8 g11_8 200
RD10_9 p10_9 d10_9 5k
M10_9 d10_9 g10_9 0 0 nm W=10u L=1u
Rpv10_9 p10_9 p10_10 20
Rgv10_9 g10_9 g10_10 200
Rph10_9 p10_9 p11_9 20
Rgh10_9 g10_9 g11_9 200
RD10_10 p10_10 d10_10 5k
M10_10 d10_10 g10_10 0 0 nm W=10u L=1u
Rpv10_10 p10_10 p10_11 20
Rgv10_10 g10_10 g10_11 200
Rph10_10 p10_10 p11_10 20
Rgh10_10 g10_10 g11_10 200
RD10_11 p10_11 d10_11 5k
M10_11 d10_11 g10_11 0 0 nm W=10u L=1u
Rpv10_11 p10_11 p10_12 20
Rgv10_11 g10_11 g10_12 200
Rph10_11 p10_11 p11_11 20
Rgh10_11 g10_11 g11_11 200
RD10_12 p10_12 d10_12 5k
M10_12 d10_12 g10_12 0 0 nm W=10u L=1u
Rpv10_12 p10_12 p10_13 20
Rgv10_12 g10_12 g10_13 200
Rph10_12 p10_12 p11_12 20
Rgh10_12 g10_12 g11_12 200
RD10_13 p10_13 d10_13 5k
M10_13 d10_13 g10_13 0 0 nm W=10u L=1u
Rpv10_13 p10_13 p10_14 20
Rgv10_13 g10_13 g10_14 200
Rph10_13 p10_13 p11_13 20
Rgh10_13 g10_13 g11_13 200
RD10_14 p10_14 d10_14 5k
M10_14 d10_14 g10_14 0 0 nm W=10u L=1u
Rpv10_14 p10_14 p10_15 20
Rgv10_14 g10_14 g10_15 200
Rph10_14 p10_14 p11_14 20
Rgh10_14 g10_14 g11_14 200
RD10_15 p10_15 d10_15 5k
M10_15 d10_15 g10_15 0 0 nm W=10u L=1u
Rpv10_15 p10_15 p10_16 20
Rgv10_15 g10_15 g10_16 200
Rph10_15 p10_15 p11_15 20
Rgh10_15 g10_15 g11_15 200
RD10_16 p10_16 d10_16 5k
M10_16 d10_16 g10_16 0 0 nm W=10u L=1u
Rpv10_16 p10_16 p10_17 20
Rgv10_16 g10_16 g10_17 200
Rph10_16 p10_16 p11_16 20
Rgh10_16 g10_16 g11_16 200
RD10_17 p10_17 d10_17 5k
M10_17 d10_17 g10_17 0 0 nm W=10u L=1u
Rpv10_17 p10_17 p10_18 20
Rgv10_17 g10_17 g10_18 200
Rph10_17 p10_17 p11_17 20
Rgh10_17 g10_17 g11_17 200
RD10_18 p10_18 d10_18 5k
M10_18 d10_18 g10_18 0 0 nm W=10u L=1u
Rpv10_18 p10_18 p10_19 20
Rgv10_18 g10_18 g10_19 200
Rph10_18 p10_18 p11_18 20
Rgh10_18 g10_18 g11_18 200
RD10_19 p10_19 d10_19 5k
M10_19 d10_19 g10_19 0 0 nm W=10u L=1u
Rph10_19 p10_19 p11_19 20
Rgh10_19 g10_19 g11_19 200
RD11_0 p11_0 d11_0 5k
M11_0 d11_0 g11_0 0 0 nm W=10u L=1u
Rpv11_0 p11_0 p11_1 20
Rgv11_0 g11_0 g11_1 200
Rph11_0 p11_0 p12_0 20
Rgh11_0 g11_0 g12_0 200
RD11_1 p11_1 d11_1 5k
M11_1 d11_1 g11_1 0 0 nm W=10u L=1u
Rpv11_1 p11_1 p11_2 20
Rgv11_1 g11_1 g11_2 200
Rph11_1 p11_1 p12_1 20
Rgh11_1 g11_1 g12_1 200
RD11_2 p11_2 d11_2 5k
M11_2 d11_2 g11_2 0 0 nm W=10u L=1u
Rpv11_2 p11_2 p11_3 20
Rgv11_2 g11_2 g11_3 200
Rph11_2 p11_2 p12_2 20
Rgh11_2 g11_2 g12_2 200
RD11_3 p11_3 d11_3 5k
M11_3 d11_3 g11_3 0 0 nm W=10u L=1u
Rpv11_3 p11_3 p11_4 20
Rgv11_3 g11_3 g11_4 200
Rph11_3 p11_3 p12_3 20
Rgh11_3 g11_3 g12_3 200
RD11_4 p11_4 d11_4 5k
M11_4 d11_4 g11_4 0 0 nm W=10u L=1u
Rpv11_4 p11_4 p11_5 20
Rgv11_4 g11_4 g11_5 200
Rph11_4 p11_4 p12_4 20
Rgh11_4 g11_4 g12_4 200
RD11_5 p11_5 d11_5 5k
M11_5 d11_5 g11_5 0 0 nm W=10u L=1u
Rpv11_5 p11_5 p11_6 20
Rgv11_5 g11_5 g11_6 200
Rph11_5 p11_5 p12_5 20
Rgh11_5 g11_5 g12_5 200
RD11_6 p11_6 d11_6 5k
M11_6 d11_6 g11_6 0 0 nm W=10u L=1u
Rpv11_6 p11_6 p11_7 20
Rgv11_6 g11_6 g11_7 200
Rph11_6 p11_6 p12_6 20
Rgh11_6 g11_6 g12_6 200
RD11_7 p11_7 d11_7 5k
M11_7 d11_7 g11_7 0 0 nm W=10u L=1u
Rpv11_7 p11_7 p11_8 20
Rgv11_7 g11_7 g11_8 200
Rph11_7 p11_7 p12_7 20
Rgh11_7 g11_7 g12_7 200
RD11_8 p11_8 d11_8 5k
M11_8 d11_8 g11_8 0 0 nm W=10u L=1u
Rpv11_8 p11_8 p11_9 20
Rgv11_8 g11_8 g11_9 200
Rph11_8 p11_8 p12_8 20
Rgh11_8 g11_8 g12_8 200
RD11_9 p11_9 d11_9 5k
M11_9 d11_9 g11_9 0 0 nm W=10u L=1u
Rpv11_9 p11_9 p11_10 20
Rgv11_9 g11_9 g11_10 200
Rph11_9 p11_9 p12_9 20
Rgh11_9 g11_9 g12_9 200
RD11_10 p11_10 d11_10 5k
M11_10 d11_10 g11_10 0 0 nm W=10u L=1u
Rpv11_10 p11_10 p11_11 20
Rgv11_10 g11_10 g11_11 200
Rph11_10 p11_10 p12_10 20
Rgh11_10 g11_10 g12_10 200
RD11_11 p11_11 d11_11 5k
M11_11 d11_11 g11_11 0 0 nm W=10u L=1u
Rpv11_11 p11_11 p11_12 20
Rgv11_11 g11_11 g11_12 200
Rph11_11 p11_11 p12_11 20
Rgh11_11 g11_11 g12_11 200
RD11_12 p11_12 d11_12 5k
M11_12 d11_12 g11_12 0 0 nm W=10u L=1u
Rpv11_12 p11_12 p11_13 20
Rgv11_12 g11_12 g11_13 200
Rph11_12 p11_12 p12_12 20
Rgh11_12 g11_12 g12_12 200
RD11_13 p11_13 d11_13 5k
M11_13 d11_13 g11_13 0 0 nm W=10u L=1u
Rpv11_13 p11_13 p11_14 20
Rgv11_13 g11_13 g11_14 200
Rph11_13 p11_13 p12_13 20
Rgh11_13 g11_13 g12_13 200
RD11_14 p11_14 d11_14 5k
M11_14 d11_14 g11_14 0 0 nm W=10u L=1u
Rpv11_14 p11_14 p11_15 20
Rgv11_14 g11_14 g11_15 200
Rph11_14 p11_14 p12_14 20
Rgh11_14 g11_14 g12_14 200
RD11_15 p11_15 d11_15 5k
M11_15 d11_15 g11_15 0 0 nm W=10u L=1u
Rpv11_15 p11_15 p11_16 20
Rgv11_15 g11_15 g11_16 200
Rph11_15 p11_15 p12_15 20
Rgh11_15 g11_15 g12_15 200
RD11_16 p11_16 d11_16 5k
M11_16 d11_16 g11_16 0 0 nm W=10u L=1u
Rpv11_16 p11_16 p11_17 20
Rgv11_16 g11_16 g11_17 200
Rph11_16 p11_16 p12_16 20
Rgh11_16 g11_16 g12_16 200
RD11_17 p11_17 d11_17 5k
M11_17 d11_17 g11_17 0 0 nm W=10u L=1u
Rpv11_17 p11_17 p11_18 20
Rgv11_17 g11_17 g11_18 200
Rph11_17 p11_17 p12_17 20
Rgh11_17 g11_17 g12_17 200
RD11_18 p11_18 d11_18 5k
M11_18 d11_18 g11_18 0 0 nm W=10u L=1u
Rpv11_18 p11_18 p11_19 20
Rgv11_18 g11_18 g11_19 200
Rph11_18 p11_18 p12_18 20
Rgh11_18 g11_18 g12_18 200
RD11_19 p11_19 d11_19 5k
M11_19 d11_19 g11_19 0 0 nm W=10u L=1u
Rph11_19 p11_19 p12_19 20
Rgh11_19 g11_19 g12_19 200
RD12_0 p12_0 d12_0 5k
M12_0 d12_0 g12_0 0 0 nm W=10u L=1u
Rpv12_0 p12_0 p12_1 20
Rgv12_0 g12_0 g12_1 200
Rph12_0 p12_0 p13_0 20
Rgh12_0 g12_0 g13_0 200
RD12_1 p12_1 d12_1 5k
M12_1 d12_1 g12_1 0 0 nm W=10u L=1u
Rpv12_1 p12_1 p12_2 20
Rgv12_1 g12_1 g12_2 200
Rph12_1 p12_1 p13_1 20
Rgh12_1 g12_1 g13_1 200
RD12_2 p12_2 d12_2 5k
M12_2 d12_2 g12_2 0 0 nm W=10u L=1u
Rpv12_2 p12_2 p12_3 20
Rgv12_2 g12_2 g12_3 200
Rph12_2 p12_2 p13_2 20
Rgh12_2 g12_2 g13_2 200
RD12_3 p12_3 d12_3 5k
M12_3 d12_3 g12_3 0 0 nm W=10u L=1u
Rpv12_3 p12_3 p12_4 20
Rgv12_3 g12_3 g12_4 200
Rph12_3 p12_3 p13_3 20
Rgh12_3 g12_3 g13_3 200
RD12_4 p12_4 d12_4 5k
M12_4 d12_4 g12_4 0 0 nm W=10u L=1u
Rpv12_4 p12_4 p12_5 20
Rgv12_4 g12_4 g12_5 200
Rph12_4 p12_4 p13_4 20
Rgh12_4 g12_4 g13_4 200
RD12_5 p12_5 d12_5 5k
M12_5 d12_5 g12_5 0 0 nm W=10u L=1u
Rpv12_5 p12_5 p12_6 20
Rgv12_5 g12_5 g12_6 200
Rph12_5 p12_5 p13_5 20
Rgh12_5 g12_5 g13_5 200
RD12_6 p12_6 d12_6 5k
M12_6 d12_6 g12_6 0 0 nm W=10u L=1u
Rpv12_6 p12_6 p12_7 20
Rgv12_6 g12_6 g12_7 200
Rph12_6 p12_6 p13_6 20
Rgh12_6 g12_6 g13_6 200
RD12_7 p12_7 d12_7 5k
M12_7 d12_7 g12_7 0 0 nm W=10u L=1u
Rpv12_7 p12_7 p12_8 20
Rgv12_7 g12_7 g12_8 200
Rph12_7 p12_7 p13_7 20
Rgh12_7 g12_7 g13_7 200
RD12_8 p12_8 d12_8 5k
M12_8 d12_8 g12_8 0 0 nm W=10u L=1u
Rpv12_8 p12_8 p12_9 20
Rgv12_8 g12_8 g12_9 200
Rph12_8 p12_8 p13_8 20
Rgh12_8 g12_8 g13_8 200
RD12_9 p12_9 d12_9 5k
M12_9 d12_9 g12_9 0 0 nm W=10u L=1u
Rpv12_9 p12_9 p12_10 20
Rgv12_9 g12_9 g12_10 200
Rph12_9 p12_9 p13_9 20
Rgh12_9 g12_9 g13_9 200
RD12_10 p12_10 d12_10 5k
M12_10 d12_10 g12_10 0 0 nm W=10u L=1u
Rpv12_10 p12_10 p12_11 20
Rgv12_10 g12_10 g12_11 200
Rph12_10 p12_10 p13_10 20
Rgh12_10 g12_10 g13_10 200
RD12_11 p12_11 d12_11 5k
M12_11 d12_11 g12_11 0 0 nm W=10u L=1u
Rpv12_11 p12_11 p12_12 20
Rgv12_11 g12_11 g12_12 200
Rph12_11 p12_11 p13_11 20
Rgh12_11 g12_11 g13_11 200
RD12_12 p12_12 d12_12 5k
M12_12 d12_12 g12_12 0 0 nm W=10u L=1u
Rpv12_12 p12_12 p12_13 20
Rgv12_12 g12_12 g12_13 200
Rph12_12 p12_12 p13_12 20
Rgh12_12 g12_12 g13_12 200
RD12_13 p12_13 d12_13 5k
M12_13 d12_13 g12_13 0 0 nm W=10u L=1u
Rpv12_13 p12_13 p12_14 20
Rgv12_13 g12_13 g12_14 200
Rph12_13 p12_13 p13_13 20
Rgh12_13 g12_13 g13_13 200
RD12_14 p12_14 d12_14 5k
M12_14 d12_14 g12_14 0 0 nm W=10u L=1u
Rpv12_14 p12_14 p12_15 20
Rgv12_14 g12_14 g12_15 200
Rph12_14 p12_14 p13_14 20
Rgh12_14 g12_14 g13_14 200
RD12_15 p12_15 d12_15 5k
M12_15 d12_15 g12_15 0 0 nm W=10u L=1u
Rpv12_15 p12_15 p12_16 20
Rgv12_15 g12_15 g12_16 200
Rph12_15 p12_15 p13_15 20
Rgh12_15 g12_15 g13_15 200
RD12_16 p12_16 d12_16 5k
M12_16 d12_16 g12_16 0 0 nm W=10u L=1u
Rpv12_16 p12_16 p12_17 20
Rgv12_16 g12_16 g12_17 200
Rph12_16 p12_16 p13_16 20
Rgh12_16 g12_16 g13_16 200
RD12_17 p12_17 d12_17 5k
M12_17 d12_17 g12_17 0 0 nm W=10u L=1u
Rpv12_17 p12_17 p12_18 20
Rgv12_17 g12_17 g12_18 200
Rph12_17 p12_17 p13_17 20
Rgh12_17 g12_17 g13_17 200
RD12_18 p12_18 d12_18 5k
M12_18 d12_18 g12_18 0 0 nm W=10u L=1u
Rpv12_18 p12_18 p12_19 20
Rgv12_18 g12_18 g12_19 200
Rph12_18 p12_18 p13_18 20
Rgh12_18 g12_18 g13_18 200
RD12_19 p12_19 d12_19 5k
M12_19 d12_19 g12_19 0 0 nm W=10u L=1u
Rph12_19 p12_19 p13_19 20
Rgh12_19 g12_19 g13_19 200
RD13_0 p13_0 d13_0 5k
M13_0 d13_0 g13_0 0 0 nm W=10u L=1u
Rpv13_0 p13_0 p13_1 20
Rgv13_0 g13_0 g13_1 200
Rph13_0 p13_0 p14_0 20
Rgh13_0 g13_0 g14_0 200
RD13_1 p13_1 d13_1 5k
M13_1 d13_1 g13_1 0 0 nm W=10u L=1u
Rpv13_1 p13_1 p13_2 20
Rgv13_1 g13_1 g13_2 200
Rph13_1 p13_1 p14_1 20
Rgh13_1 g13_1 g14_1 200
RD13_2 p13_2 d13_2 5k
M13_2 d13_2 g13_2 0 0 nm W=10u L=1u
Rpv13_2 p13_2 p13_3 20
Rgv13_2 g13_2 g13_3 200
Rph13_2 p13_2 p14_2 20
Rgh13_2 g13_2 g14_2 200
RD13_3 p13_3 d13_3 5k
M13_3 d13_3 g13_3 0 0 nm W=10u L=1u
Rpv13_3 p13_3 p13_4 20
Rgv13_3 g13_3 g13_4 200
Rph13_3 p13_3 p14_3 20
Rgh13_3 g13_3 g14_3 200
RD13_4 p13_4 d13_4 5k
M13_4 d13_4 g13_4 0 0 nm W=10u L=1u
Rpv13_4 p13_4 p13_5 20
Rgv13_4 g13_4 g13_5 200
Rph13_4 p13_4 p14_4 20
Rgh13_4 g13_4 g14_4 200
RD13_5 p13_5 d13_5 5k
M13_5 d13_5 g13_5 0 0 nm W=10u L=1u
Rpv13_5 p13_5 p13_6 20
Rgv13_5 g13_5 g13_6 200
Rph13_5 p13_5 p14_5 20
Rgh13_5 g13_5 g14_5 200
RD13_6 p13_6 d13_6 5k
M13_6 d13_6 g13_6 0 0 nm W=10u L=1u
Rpv13_6 p13_6 p13_7 20
Rgv13_6 g13_6 g13_7 200
Rph13_6 p13_6 p14_6 20
Rgh13_6 g13_6 g14_6 200
RD13_7 p13_7 d13_7 5k
M13_7 d13_7 g13_7 0 0 nm W=10u L=1u
Rpv13_7 p13_7 p13_8 20
Rgv13_7 g13_7 g13_8 200
Rph13_7 p13_7 p14_7 20
Rgh13_7 g13_7 g14_7 200
RD13_8 p13_8 d13_8 5k
M13_8 d13_8 g13_8 0 0 nm W=10u L=1u
Rpv13_8 p13_8 p13_9 20
Rgv13_8 g13_8 g13_9 200
Rph13_8 p13_8 p14_8 20
Rgh13_8 g13_8 g14_8 200
RD13_9 p13_9 d13_9 5k
M13_9 d13_9 g13_9 0 0 nm W=10u L=1u
Rpv13_9 p13_9 p13_10 20
Rgv13_9 g13_9 g13_10 200
Rph13_9 p13_9 p14_9 20
Rgh13_9 g13_9 g14_9 200
RD13_10 p13_10 d13_10 5k
M13_10 d13_10 g13_10 0 0 nm W=10u L=1u
Rpv13_10 p13_10 p13_11 20
Rgv13_10 g13_10 g13_11 200
Rph13_10 p13_10 p14_10 20
Rgh13_10 g13_10 g14_10 200
RD13_11 p13_11 d13_11 5k
M13_11 d13_11 g13_11 0 0 nm W=10u L=1u
Rpv13_11 p13_11 p13_12 20
Rgv13_11 g13_11 g13_12 200
Rph13_11 p13_11 p14_11 20
Rgh13_11 g13_11 g14_11 200
RD13_12 p13_12 d13_12 5k
M13_12 d13_12 g13_12 0 0 nm W=10u L=1u
Rpv13_12 p13_12 p13_13 20
Rgv13_12 g13_12 g13_13 200
Rph13_12 p13_12 p14_12 20
Rgh13_12 g13_12 g14_12 200
RD13_13 p13_13 d13_13 5k
M13_13 d13_13 g13_13 0 0 nm W=10u L=1u
Rpv13_13 p13_13 p13_14 20
Rgv13_13 g13_13 g13_14 200
Rph13_13 p13_13 p14_13 20
Rgh13_13 g13_13 g14_13 200
RD13_14 p13_14 d13_14 5k
M13_14 d13_14 g13_14 0 0 nm W=10u L=1u
Rpv13_14 p13_14 p13_15 20
Rgv13_14 g13_14 g13_15 200
Rph13_14 p13_14 p14_14 20
Rgh13_14 g13_14 g14_14 200
RD13_15 p13_15 d13_15 5k
M13_15 d13_15 g13_15 0 0 nm W=10u L=1u
Rpv13_15 p13_15 p13_16 20
Rgv13_15 g13_15 g13_16 200
Rph13_15 p13_15 p14_15 20
Rgh13_15 g13_15 g14_15 200
RD13_16 p13_16 d13_16 5k
M13_16 d13_16 g13_16 0 0 nm W=10u L=1u
Rpv13_16 p13_16 p13_17 20
Rgv13_16 g13_16 g13_17 200
Rph13_16 p13_16 p14_16 20
Rgh13_16 g13_16 g14_16 200
RD13_17 p13_17 d13_17 5k
M13_17 d13_17 g13_17 0 0 nm W=10u L=1u
Rpv13_17 p13_17 p13_18 20
Rgv13_17 g13_17 g13_18 200
Rph13_17 p13_17 p14_17 20
Rgh13_17 g13_17 g14_17 200
RD13_18 p13_18 d13_18 5k
M13_18 d13_18 g13_18 0 0 nm W=10u L=1u
Rpv13_18 p13_18 p13_19 20
Rgv13_18 g13_18 g13_19 200
Rph13_18 p13_18 p14_18 20
Rgh13_18 g13_18 g14_18 200
RD13_19 p13_19 d13_19 5k
M13_19 d13_19 g13_19 0 0 nm W=10u L=1u
Rph13_19 p13_19 p14_19 20
Rgh13_19 g13_19 g14_19 200
RD14_0 p14_0 d14_0 5k
M14_0 d14_0 g14_0 0 0 nm W=10u L=1u
Rpv14_0 p14_0 p14_1 20
Rgv14_0 g14_0 g14_1 200
Rph14_0 p14_0 p15_0 20
Rgh14_0 g14_0 g15_0 200
RD14_1 p14_1 d14_1 5k
M14_1 d14_1 g14_1 0 0 nm W=10u L=1u
Rpv14_1 p14_1 p14_2 20
Rgv14_1 g14_1 g14_2 200
Rph14_1 p14_1 p15_1 20
Rgh14_1 g14_1 g15_1 200
RD14_2 p14_2 d14_2 5k
M14_2 d14_2 g14_2 0 0 nm W=10u L=1u
Rpv14_2 p14_2 p14_3 20
Rgv14_2 g14_2 g14_3 200
Rph14_2 p14_2 p15_2 20
Rgh14_2 g14_2 g15_2 200
RD14_3 p14_3 d14_3 5k
M14_3 d14_3 g14_3 0 0 nm W=10u L=1u
Rpv14_3 p14_3 p14_4 20
Rgv14_3 g14_3 g14_4 200
Rph14_3 p14_3 p15_3 20
Rgh14_3 g14_3 g15_3 200
RD14_4 p14_4 d14_4 5k
M14_4 d14_4 g14_4 0 0 nm W=10u L=1u
Rpv14_4 p14_4 p14_5 20
Rgv14_4 g14_4 g14_5 200
Rph14_4 p14_4 p15_4 20
Rgh14_4 g14_4 g15_4 200
RD14_5 p14_5 d14_5 5k
M14_5 d14_5 g14_5 0 0 nm W=10u L=1u
Rpv14_5 p14_5 p14_6 20
Rgv14_5 g14_5 g14_6 200
Rph14_5 p14_5 p15_5 20
Rgh14_5 g14_5 g15_5 200
RD14_6 p14_6 d14_6 5k
M14_6 d14_6 g14_6 0 0 nm W=10u L=1u
Rpv14_6 p14_6 p14_7 20
Rgv14_6 g14_6 g14_7 200
Rph14_6 p14_6 p15_6 20
Rgh14_6 g14_6 g15_6 200
RD14_7 p14_7 d14_7 5k
M14_7 d14_7 g14_7 0 0 nm W=10u L=1u
Rpv14_7 p14_7 p14_8 20
Rgv14_7 g14_7 g14_8 200
Rph14_7 p14_7 p15_7 20
Rgh14_7 g14_7 g15_7 200
RD14_8 p14_8 d14_8 5k
M14_8 d14_8 g14_8 0 0 nm W=10u L=1u
Rpv14_8 p14_8 p14_9 20
Rgv14_8 g14_8 g14_9 200
Rph14_8 p14_8 p15_8 20
Rgh14_8 g14_8 g15_8 200
RD14_9 p14_9 d14_9 5k
M14_9 d14_9 g14_9 0 0 nm W=10u L=1u
Rpv14_9 p14_9 p14_10 20
Rgv14_9 g14_9 g14_10 200
Rph14_9 p14_9 p15_9 20
Rgh14_9 g14_9 g15_9 200
RD14_10 p14_10 d14_10 5k
M14_10 d14_10 g14_10 0 0 nm W=10u L=1u
Rpv14_10 p14_10 p14_11 20
Rgv14_10 g14_10 g14_11 200
Rph14_10 p14_10 p15_10 20
Rgh14_10 g14_10 g15_10 200
RD14_11 p14_11 d14_11 5k
M14_11 d14_11 g14_11 0 0 nm W=10u L=1u
Rpv14_11 p14_11 p14_12 20
Rgv14_11 g14_11 g14_12 200
Rph14_11 p14_11 p15_11 20
Rgh14_11 g14_11 g15_11 200
RD14_12 p14_12 d14_12 5k
M14_12 d14_12 g14_12 0 0 nm W=10u L=1u
Rpv14_12 p14_12 p14_13 20
Rgv14_12 g14_12 g14_13 200
Rph14_12 p14_12 p15_12 20
Rgh14_12 g14_12 g15_12 200
RD14_13 p14_13 d14_13 5k
M14_13 d14_13 g14_13 0 0 nm W=10u L=1u
Rpv14_13 p14_13 p14_14 20
Rgv14_13 g14_13 g14_14 200
Rph14_13 p14_13 p15_13 20
Rgh14_13 g14_13 g15_13 200
RD14_14 p14_14 d14_14 5k
M14_14 d14_14 g14_14 0 0 nm W=10u L=1u
Rpv14_14 p14_14 p14_15 20
Rgv14_14 g14_14 g14_15 200
Rph14_14 p14_14 p15_14 20
Rgh14_14 g14_14 g15_14 200
RD14_15 p14_15 d14_15 5k
M14_15 d14_15 g14_15 0 0 nm W=10u L=1u
Rpv14_15 p14_15 p14_16 20
Rgv14_15 g14_15 g14_16 200
Rph14_15 p14_15 p15_15 20
Rgh14_15 g14_15 g15_15 200
RD14_16 p14_16 d14_16 5k
M14_16 d14_16 g14_16 0 0 nm W=10u L=1u
Rpv14_16 p14_16 p14_17 20
Rgv14_16 g14_16 g14_17 200
Rph14_16 p14_16 p15_16 20
Rgh14_16 g14_16 g15_16 200
RD14_17 p14_17 d14_17 5k
M14_17 d14_17 g14_17 0 0 nm W=10u L=1u
Rpv14_17 p14_17 p14_18 20
Rgv14_17 g14_17 g14_18 200
Rph14_17 p14_17 p15_17 20
Rgh14_17 g14_17 g15_17 200
RD14_18 p14_18 d14_18 5k
M14_18 d14_18 g14_18 0 0 nm W=10u L=1u
Rpv14_18 p14_18 p14_19 20
Rgv14_18 g14_18 g14_19 200
Rph14_18 p14_18 p15_18 20
Rgh14_18 g14_18 g15_18 200
RD14_19 p14_19 d14_19 5k
M14_19 d14_19 g14_19 0 0 nm W=10u L=1u
Rph14_19 p14_19 p15_19 20
Rgh14_19 g14_19 g15_19 200
RD15_0 p15_0 d15_0 5k
M15_0 d15_0 g15_0 0 0 nm W=10u L=1u
Rpv15_0 p15_0 p15_1 20
Rgv15_0 g15_0 g15_1 200
Rph15_0 p15_0 p16_0 20
Rgh15_0 g15_0 g16_0 200
RD15_1 p15_1 d15_1 5k
M15_1 d15_1 g15_1 0 0 nm W=10u L=1u
Rpv15_1 p15_1 p15_2 20
Rgv15_1 g15_1 g15_2 200
Rph15_1 p15_1 p16_1 20
Rgh15_1 g15_1 g16_1 200
RD15_2 p15_2 d15_2 5k
M15_2 d15_2 g15_2 0 0 nm W=10u L=1u
Rpv15_2 p15_2 p15_3 20
Rgv15_2 g15_2 g15_3 200
Rph15_2 p15_2 p16_2 20
Rgh15_2 g15_2 g16_2 200
RD15_3 p15_3 d15_3 5k
M15_3 d15_3 g15_3 0 0 nm W=10u L=1u
Rpv15_3 p15_3 p15_4 20
Rgv15_3 g15_3 g15_4 200
Rph15_3 p15_3 p16_3 20
Rgh15_3 g15_3 g16_3 200
RD15_4 p15_4 d15_4 5k
M15_4 d15_4 g15_4 0 0 nm W=10u L=1u
Rpv15_4 p15_4 p15_5 20
Rgv15_4 g15_4 g15_5 200
Rph15_4 p15_4 p16_4 20
Rgh15_4 g15_4 g16_4 200
RD15_5 p15_5 d15_5 5k
M15_5 d15_5 g15_5 0 0 nm W=10u L=1u
Rpv15_5 p15_5 p15_6 20
Rgv15_5 g15_5 g15_6 200
Rph15_5 p15_5 p16_5 20
Rgh15_5 g15_5 g16_5 200
RD15_6 p15_6 d15_6 5k
M15_6 d15_6 g15_6 0 0 nm W=10u L=1u
Rpv15_6 p15_6 p15_7 20
Rgv15_6 g15_6 g15_7 200
Rph15_6 p15_6 p16_6 20
Rgh15_6 g15_6 g16_6 200
RD15_7 p15_7 d15_7 5k
M15_7 d15_7 g15_7 0 0 nm W=10u L=1u
Rpv15_7 p15_7 p15_8 20
Rgv15_7 g15_7 g15_8 200
Rph15_7 p15_7 p16_7 20
Rgh15_7 g15_7 g16_7 200
RD15_8 p15_8 d15_8 5k
M15_8 d15_8 g15_8 0 0 nm W=10u L=1u
Rpv15_8 p15_8 p15_9 20
Rgv15_8 g15_8 g15_9 200
Rph15_8 p15_8 p16_8 20
Rgh15_8 g15_8 g16_8 200
RD15_9 p15_9 d15_9 5k
M15_9 d15_9 g15_9 0 0 nm W=10u L=1u
Rpv15_9 p15_9 p15_10 20
Rgv15_9 g15_9 g15_10 200
Rph15_9 p15_9 p16_9 20
Rgh15_9 g15_9 g16_9 200
RD15_10 p15_10 d15_10 5k
M15_10 d15_10 g15_10 0 0 nm W=10u L=1u
Rpv15_10 p15_10 p15_11 20
Rgv15_10 g15_10 g15_11 200
Rph15_10 p15_10 p16_10 20
Rgh15_10 g15_10 g16_10 200
RD15_11 p15_11 d15_11 5k
M15_11 d15_11 g15_11 0 0 nm W=10u L=1u
Rpv15_11 p15_11 p15_12 20
Rgv15_11 g15_11 g15_12 200
Rph15_11 p15_11 p16_11 20
Rgh15_11 g15_11 g16_11 200
RD15_12 p15_12 d15_12 5k
M15_12 d15_12 g15_12 0 0 nm W=10u L=1u
Rpv15_12 p15_12 p15_13 20
Rgv15_12 g15_12 g15_13 200
Rph15_12 p15_12 p16_12 20
Rgh15_12 g15_12 g16_12 200
RD15_13 p15_13 d15_13 5k
M15_13 d15_13 g15_13 0 0 nm W=10u L=1u
Rpv15_13 p15_13 p15_14 20
Rgv15_13 g15_13 g15_14 200
Rph15_13 p15_13 p16_13 20
Rgh15_13 g15_13 g16_13 200
RD15_14 p15_14 d15_14 5k
M15_14 d15_14 g15_14 0 0 nm W=10u L=1u
Rpv15_14 p15_14 p15_15 20
Rgv15_14 g15_14 g15_15 200
Rph15_14 p15_14 p16_14 20
Rgh15_14 g15_14 g16_14 200
RD15_15 p15_15 d15_15 5k
M15_15 d15_15 g15_15 0 0 nm W=10u L=1u
Rpv15_15 p15_15 p15_16 20
Rgv15_15 g15_15 g15_16 200
Rph15_15 p15_15 p16_15 20
Rgh15_15 g15_15 g16_15 200
RD15_16 p15_16 d15_16 5k
M15_16 d15_16 g15_16 0 0 nm W=10u L=1u
Rpv15_16 p15_16 p15_17 20
Rgv15_16 g15_16 g15_17 200
Rph15_16 p15_16 p16_16 20
Rgh15_16 g15_16 g16_16 200
RD15_17 p15_17 d15_17 5k
M15_17 d15_17 g15_17 0 0 nm W=10u L=1u
Rpv15_17 p15_17 p15_18 20
Rgv15_17 g15_17 g15_18 200
Rph15_17 p15_17 p16_17 20
Rgh15_17 g15_17 g16_17 200
RD15_18 p15_18 d15_18 5k
M15_18 d15_18 g15_18 0 0 nm W=10u L=1u
Rpv15_18 p15_18 p15_19 20
Rgv15_18 g15_18 g15_19 200
Rph15_18 p15_18 p16_18 20
Rgh15_18 g15_18 g16_18 200
RD15_19 p15_19 d15_19 5k
M15_19 d15_19 g15_19 0 0 nm W=10u L=1u
Rph15_19 p15_19 p16_19 20
Rgh15_19 g15_19 g16_19 200
RD16_0 p16_0 d16_0 5k
M16_0 d16_0 g16_0 0 0 nm W=10u L=1u
Rpv16_0 p16_0 p16_1 20
Rgv16_0 g16_0 g16_1 200
Rph16_0 p16_0 p17_0 20
Rgh16_0 g16_0 g17_0 200
RD16_1 p16_1 d16_1 5k
M16_1 d16_1 g16_1 0 0 nm W=10u L=1u
Rpv16_1 p16_1 p16_2 20
Rgv16_1 g16_1 g16_2 200
Rph16_1 p16_1 p17_1 20
Rgh16_1 g16_1 g17_1 200
RD16_2 p16_2 d16_2 5k
M16_2 d16_2 g16_2 0 0 nm W=10u L=1u
Rpv16_2 p16_2 p16_3 20
Rgv16_2 g16_2 g16_3 200
Rph16_2 p16_2 p17_2 20
Rgh16_2 g16_2 g17_2 200
RD16_3 p16_3 d16_3 5k
M16_3 d16_3 g16_3 0 0 nm W=10u L=1u
Rpv16_3 p16_3 p16_4 20
Rgv16_3 g16_3 g16_4 200
Rph16_3 p16_3 p17_3 20
Rgh16_3 g16_3 g17_3 200
RD16_4 p16_4 d16_4 5k
M16_4 d16_4 g16_4 0 0 nm W=10u L=1u
Rpv16_4 p16_4 p16_5 20
Rgv16_4 g16_4 g16_5 200
Rph16_4 p16_4 p17_4 20
Rgh16_4 g16_4 g17_4 200
RD16_5 p16_5 d16_5 5k
M16_5 d16_5 g16_5 0 0 nm W=10u L=1u
Rpv16_5 p16_5 p16_6 20
Rgv16_5 g16_5 g16_6 200
Rph16_5 p16_5 p17_5 20
Rgh16_5 g16_5 g17_5 200
RD16_6 p16_6 d16_6 5k
M16_6 d16_6 g16_6 0 0 nm W=10u L=1u
Rpv16_6 p16_6 p16_7 20
Rgv16_6 g16_6 g16_7 200
Rph16_6 p16_6 p17_6 20
Rgh16_6 g16_6 g17_6 200
RD16_7 p16_7 d16_7 5k
M16_7 d16_7 g16_7 0 0 nm W=10u L=1u
Rpv16_7 p16_7 p16_8 20
Rgv16_7 g16_7 g16_8 200
Rph16_7 p16_7 p17_7 20
Rgh16_7 g16_7 g17_7 200
RD16_8 p16_8 d16_8 5k
M16_8 d16_8 g16_8 0 0 nm W=10u L=1u
Rpv16_8 p16_8 p16_9 20
Rgv16_8 g16_8 g16_9 200
Rph16_8 p16_8 p17_8 20
Rgh16_8 g16_8 g17_8 200
RD16_9 p16_9 d16_9 5k
M16_9 d16_9 g16_9 0 0 nm W=10u L=1u
Rpv16_9 p16_9 p16_10 20
Rgv16_9 g16_9 g16_10 200
Rph16_9 p16_9 p17_9 20
Rgh16_9 g16_9 g17_9 200
RD16_10 p16_10 d16_10 5k
M16_10 d16_10 g16_10 0 0 nm W=10u L=1u
Rpv16_10 p16_10 p16_11 20
Rgv16_10 g16_10 g16_11 200
Rph16_10 p16_10 p17_10 20
Rgh16_10 g16_10 g17_10 200
RD16_11 p16_11 d16_11 5k
M16_11 d16_11 g16_11 0 0 nm W=10u L=1u
Rpv16_11 p16_11 p16_12 20
Rgv16_11 g16_11 g16_12 200
Rph16_11 p16_11 p17_11 20
Rgh16_11 g16_11 g17_11 200
RD16_12 p16_12 d16_12 5k
M16_12 d16_12 g16_12 0 0 nm W=10u L=1u
Rpv16_12 p16_12 p16_13 20
Rgv16_12 g16_12 g16_13 200
Rph16_12 p16_12 p17_12 20
Rgh16_12 g16_12 g17_12 200
RD16_13 p16_13 d16_13 5k
M16_13 d16_13 g16_13 0 0 nm W=10u L=1u
Rpv16_13 p16_13 p16_14 20
Rgv16_13 g16_13 g16_14 200
Rph16_13 p16_13 p17_13 20
Rgh16_13 g16_13 g17_13 200
RD16_14 p16_14 d16_14 5k
M16_14 d16_14 g16_14 0 0 nm W=10u L=1u
Rpv16_14 p16_14 p16_15 20
Rgv16_14 g16_14 g16_15 200
Rph16_14 p16_14 p17_14 20
Rgh16_14 g16_14 g17_14 200
RD16_15 p16_15 d16_15 5k
M16_15 d16_15 g16_15 0 0 nm W=10u L=1u
Rpv16_15 p16_15 p16_16 20
Rgv16_15 g16_15 g16_16 200
Rph16_15 p16_15 p17_15 20
Rgh16_15 g16_15 g17_15 200
RD16_16 p16_16 d16_16 5k
M16_16 d16_16 g16_16 0 0 nm W=10u L=1u
Rpv16_16 p16_16 p16_17 20
Rgv16_16 g16_16 g16_17 200
Rph16_16 p16_16 p17_16 20
Rgh16_16 g16_16 g17_16 200
RD16_17 p16_17 d16_17 5k
M16_17 d16_17 g16_17 0 0 nm W=10u L=1u
Rpv16_17 p16_17 p16_18 20
Rgv16_17 g16_17 g16_18 200
Rph16_17 p16_17 p17_17 20
Rgh16_17 g16_17 g17_17 200
RD16_18 p16_18 d16_18 5k
M16_18 d16_18 g16_18 0 0 nm W=10u L=1u
Rpv16_18 p16_18 p16_19 20
Rgv16_18 g16_18 g16_19 200
Rph16_18 p16_18 p17_18 20
Rgh16_18 g16_18 g17_18 200
RD16_19 p16_19 d16_19 5k
M16_19 d16_19 g16_19 0 0 nm W=10u L=1u
Rph16_19 p16_19 p17_19 20
Rgh16_19 g16_19 g17_19 200
RD17_0 p17_0 d17_0 5k
M17_0 d17_0 g17_0 0 0 nm W=10u L=1u
Rpv17_0 p17_0 p17_1 20
Rgv17_0 g17_0 g17_1 200
Rph17_0 p17_0 p18_0 20
Rgh17_0 g17_0 g18_0 200
RD17_1 p17_1 d17_1 5k
M17_1 d17_1 g17_1 0 0 nm W=10u L=1u
Rpv17_1 p17_1 p17_2 20
Rgv17_1 g17_1 g17_2 200
Rph17_1 p17_1 p18_1 20
Rgh17_1 g17_1 g18_1 200
RD17_2 p17_2 d17_2 5k
M17_2 d17_2 g17_2 0 0 nm W=10u L=1u
Rpv17_2 p17_2 p17_3 20
Rgv17_2 g17_2 g17_3 200
Rph17_2 p17_2 p18_2 20
Rgh17_2 g17_2 g18_2 200
RD17_3 p17_3 d17_3 5k
M17_3 d17_3 g17_3 0 0 nm W=10u L=1u
Rpv17_3 p17_3 p17_4 20
Rgv17_3 g17_3 g17_4 200
Rph17_3 p17_3 p18_3 20
Rgh17_3 g17_3 g18_3 200
RD17_4 p17_4 d17_4 5k
M17_4 d17_4 g17_4 0 0 nm W=10u L=1u
Rpv17_4 p17_4 p17_5 20
Rgv17_4 g17_4 g17_5 200
Rph17_4 p17_4 p18_4 20
Rgh17_4 g17_4 g18_4 200
RD17_5 p17_5 d17_5 5k
M17_5 d17_5 g17_5 0 0 nm W=10u L=1u
Rpv17_5 p17_5 p17_6 20
Rgv17_5 g17_5 g17_6 200
Rph17_5 p17_5 p18_5 20
Rgh17_5 g17_5 g18_5 200
RD17_6 p17_6 d17_6 5k
M17_6 d17_6 g17_6 0 0 nm W=10u L=1u
Rpv17_6 p17_6 p17_7 20
Rgv17_6 g17_6 g17_7 200
Rph17_6 p17_6 p18_6 20
Rgh17_6 g17_6 g18_6 200
RD17_7 p17_7 d17_7 5k
M17_7 d17_7 g17_7 0 0 nm W=10u L=1u
Rpv17_7 p17_7 p17_8 20
Rgv17_7 g17_7 g17_8 200
Rph17_7 p17_7 p18_7 20
Rgh17_7 g17_7 g18_7 200
RD17_8 p17_8 d17_8 5k
M17_8 d17_8 g17_8 0 0 nm W=10u L=1u
Rpv17_8 p17_8 p17_9 20
Rgv17_8 g17_8 g17_9 200
Rph17_8 p17_8 p18_8 20
Rgh17_8 g17_8 g18_8 200
RD17_9 p17_9 d17_9 5k
M17_9 d17_9 g17_9 0 0 nm W=10u L=1u
Rpv17_9 p17_9 p17_10 20
Rgv17_9 g17_9 g17_10 200
Rph17_9 p17_9 p18_9 20
Rgh17_9 g17_9 g18_9 200
RD17_10 p17_10 d17_10 5k
M17_10 d17_10 g17_10 0 0 nm W=10u L=1u
Rpv17_10 p17_10 p17_11 20
Rgv17_10 g17_10 g17_11 200
Rph17_10 p17_10 p18_10 20
Rgh17_10 g17_10 g18_10 200
RD17_11 p17_11 d17_11 5k
M17_11 d17_11 g17_11 0 0 nm W=10u L=1u
Rpv17_11 p17_11 p17_12 20
Rgv17_11 g17_11 g17_12 200
Rph17_11 p17_11 p18_11 20
Rgh17_11 g17_11 g18_11 200
RD17_12 p17_12 d17_12 5k
M17_12 d17_12 g17_12 0 0 nm W=10u L=1u
Rpv17_12 p17_12 p17_13 20
Rgv17_12 g17_12 g17_13 200
Rph17_12 p17_12 p18_12 20
Rgh17_12 g17_12 g18_12 200
RD17_13 p17_13 d17_13 5k
M17_13 d17_13 g17_13 0 0 nm W=10u L=1u
Rpv17_13 p17_13 p17_14 20
Rgv17_13 g17_13 g17_14 200
Rph17_13 p17_13 p18_13 20
Rgh17_13 g17_13 g18_13 200
RD17_14 p17_14 d17_14 5k
M17_14 d17_14 g17_14 0 0 nm W=10u L=1u
Rpv17_14 p17_14 p17_15 20
Rgv17_14 g17_14 g17_15 200
Rph17_14 p17_14 p18_14 20
Rgh17_14 g17_14 g18_14 200
RD17_15 p17_15 d17_15 5k
M17_15 d17_15 g17_15 0 0 nm W=10u L=1u
Rpv17_15 p17_15 p17_16 20
Rgv17_15 g17_15 g17_16 200
Rph17_15 p17_15 p18_15 20
Rgh17_15 g17_15 g18_15 200
RD17_16 p17_16 d17_16 5k
M17_16 d17_16 g17_16 0 0 nm W=10u L=1u
Rpv17_16 p17_16 p17_17 20
Rgv17_16 g17_16 g17_17 200
Rph17_16 p17_16 p18_16 20
Rgh17_16 g17_16 g18_16 200
RD17_17 p17_17 d17_17 5k
M17_17 d17_17 g17_17 0 0 nm W=10u L=1u
Rpv17_17 p17_17 p17_18 20
Rgv17_17 g17_17 g17_18 200
Rph17_17 p17_17 p18_17 20
Rgh17_17 g17_17 g18_17 200
RD17_18 p17_18 d17_18 5k
M17_18 d17_18 g17_18 0 0 nm W=10u L=1u
Rpv17_18 p17_18 p17_19 20
Rgv17_18 g17_18 g17_19 200
Rph17_18 p17_18 p18_18 20
Rgh17_18 g17_18 g18_18 200
RD17_19 p17_19 d17_19 5k
M17_19 d17_19 g17_19 0 0 nm W=10u L=1u
Rph17_19 p17_19 p18_19 20
Rgh17_19 g17_19 g18_19 200
RD18_0 p18_0 d18_0 5k
M18_0 d18_0 g18_0 0 0 nm W=10u L=1u
Rpv18_0 p18_0 p18_1 20
Rgv18_0 g18_0 g18_1 200
Rph18_0 p18_0 p19_0 20
Rgh18_0 g18_0 g19_0 200
RD18_1 p18_1 d18_1 5k
M18_1 d18_1 g18_1 0 0 nm W=10u L=1u
Rpv18_1 p18_1 p18_2 20
Rgv18_1 g18_1 g18_2 200
Rph18_1 p18_1 p19_1 20
Rgh18_1 g18_1 g19_1 200
RD18_2 p18_2 d18_2 5k
M18_2 d18_2 g18_2 0 0 nm W=10u L=1u
Rpv18_2 p18_2 p18_3 20
Rgv18_2 g18_2 g18_3 200
Rph18_2 p18_2 p19_2 20
Rgh18_2 g18_2 g19_2 200
RD18_3 p18_3 d18_3 5k
M18_3 d18_3 g18_3 0 0 nm W=10u L=1u
Rpv18_3 p18_3 p18_4 20
Rgv18_3 g18_3 g18_4 200
Rph18_3 p18_3 p19_3 20
Rgh18_3 g18_3 g19_3 200
RD18_4 p18_4 d18_4 5k
M18_4 d18_4 g18_4 0 0 nm W=10u L=1u
Rpv18_4 p18_4 p18_5 20
Rgv18_4 g18_4 g18_5 200
Rph18_4 p18_4 p19_4 20
Rgh18_4 g18_4 g19_4 200
RD18_5 p18_5 d18_5 5k
M18_5 d18_5 g18_5 0 0 nm W=10u L=1u
Rpv18_5 p18_5 p18_6 20
Rgv18_5 g18_5 g18_6 200
Rph18_5 p18_5 p19_5 20
Rgh18_5 g18_5 g19_5 200
RD18_6 p18_6 d18_6 5k
M18_6 d18_6 g18_6 0 0 nm W=10u L=1u
Rpv18_6 p18_6 p18_7 20
Rgv18_6 g18_6 g18_7 200
Rph18_6 p18_6 p19_6 20
Rgh18_6 g18_6 g19_6 200
RD18_7 p18_7 d18_7 5k
M18_7 d18_7 g18_7 0 0 nm W=10u L=1u
Rpv18_7 p18_7 p18_8 20
Rgv18_7 g18_7 g18_8 200
Rph18_7 p18_7 p19_7 20
Rgh18_7 g18_7 g19_7 200
RD18_8 p18_8 d18_8 5k
M18_8 d18_8 g18_8 0 0 nm W=10u L=1u
Rpv18_8 p18_8 p18_9 20
Rgv18_8 g18_8 g18_9 200
Rph18_8 p18_8 p19_8 20
Rgh18_8 g18_8 g19_8 200
RD18_9 p18_9 d18_9 5k
M18_9 d18_9 g18_9 0 0 nm W=10u L=1u
Rpv18_9 p18_9 p18_10 20
Rgv18_9 g18_9 g18_10 200
Rph18_9 p18_9 p19_9 20
Rgh18_9 g18_9 g19_9 200
RD18_10 p18_10 d18_10 5k
M18_10 d18_10 g18_10 0 0 nm W=10u L=1u
Rpv18_10 p18_10 p18_11 20
Rgv18_10 g18_10 g18_11 200
Rph18_10 p18_10 p19_10 20
Rgh18_10 g18_10 g19_10 200
RD18_11 p18_11 d18_11 5k
M18_11 d18_11 g18_11 0 0 nm W=10u L=1u
Rpv18_11 p18_11 p18_12 20
Rgv18_11 g18_11 g18_12 200
Rph18_11 p18_11 p19_11 20
Rgh18_11 g18_11 g19_11 200
RD18_12 p18_12 d18_12 5k
M18_12 d18_12 g18_12 0 0 nm W=10u L=1u
Rpv18_12 p18_12 p18_13 20
Rgv18_12 g18_12 g18_13 200
Rph18_12 p18_12 p19_12 20
Rgh18_12 g18_12 g19_12 200
RD18_13 p18_13 d18_13 5k
M18_13 d18_13 g18_13 0 0 nm W=10u L=1u
Rpv18_13 p18_13 p18_14 20
Rgv18_13 g18_13 g18_14 200
Rph18_13 p18_13 p19_13 20
Rgh18_13 g18_13 g19_13 200
RD18_14 p18_14 d18_14 5k
M18_14 d18_14 g18_14 0 0 nm W=10u L=1u
Rpv18_14 p18_14 p18_15 20
Rgv18_14 g18_14 g18_15 200
Rph18_14 p18_14 p19_14 20
Rgh18_14 g18_14 g19_14 200
RD18_15 p18_15 d18_15 5k
M18_15 d18_15 g18_15 0 0 nm W=10u L=1u
Rpv18_15 p18_15 p18_16 20
Rgv18_15 g18_15 g18_16 200
Rph18_15 p18_15 p19_15 20
Rgh18_15 g18_15 g19_15 200
RD18_16 p18_16 d18_16 5k
M18_16 d18_16 g18_16 0 0 nm W=10u L=1u
Rpv18_16 p18_16 p18_17 20
Rgv18_16 g18_16 g18_17 200
Rph18_16 p18_16 p19_16 20
Rgh18_16 g18_16 g19_16 200
RD18_17 p18_17 d18_17 5k
M18_17 d18_17 g18_17 0 0 nm W=10u L=1u
Rpv18_17 p18_17 p18_18 20
Rgv18_17 g18_17 g18_18 200
Rph18_17 p18_17 p19_17 20
Rgh18_17 g18_17 g19_17 200
RD18_18 p18_18 d18_18 5k
M18_18 d18_18 g18_18 0 0 nm W=10u L=1u
Rpv18_18 p18_18 p18_19 20
Rgv18_18 g18_18 g18_19 200
Rph18_18 p18_18 p19_18 20
Rgh18_18 g18_18 g19_18 200
RD18_19 p18_19 d18_19 5k
M18_19 d18_19 g18_19 0 0 nm W=10u L=1u
Rph18_19 p18_19 p19_19 20
Rgh18_19 g18_19 g19_19 200
RD19_0 p19_0 d19_0 5k
M19_0 d19_0 g19_0 0 0 nm W=10u L=1u
Rpv19_0 p19_0 p19_1 20
Rgv19_0 g19_0 g19_1 200
RD19_1 p19_1 d19_1 5k
M19_1 d19_1 g19_1 0 0 nm W=10u L=1u
Rpv19_1 p19_1 p19_2 20
Rgv19_1 g19_1 g19_2 200
RD19_2 p19_2 d19_2 5k
M19_2 d19_2 g19_2 0 0 nm W=10u L=1u
Rpv19_2 p19_2 p19_3 20
Rgv19_2 g19_2 g19_3 200
RD19_3 p19_3 d19_3 5k
M19_3 d19_3 g19_3 0 0 nm W=10u L=1u
Rpv19_3 p19_3 p19_4 20
Rgv19_3 g19_3 g19_4 200
RD19_4 p19_4 d19_4 5k
M19_4 d19_4 g19_4 0 0 nm W=10u L=1u
Rpv19_4 p19_4 p19_5 20
Rgv19_4 g19_4 g19_5 200
RD19_5 p19_5 d19_5 5k
M19_5 d19_5 g19_5 0 0 nm W=10u L=1u
Rpv19_5 p19_5 p19_6 20
Rgv19_5 g19_5 g19_6 200
RD19_6 p19_6 d19_6 5k
M19_6 d19_6 g19_6 0 0 nm W=10u L=1u
Rpv19_6 p19_6 p19_7 20
Rgv19_6 g19_6 g19_7 200
RD19_7 p19_7 d19_7 5k
M19_7 d19_7 g19_7 0 0 nm W=10u L=1u
Rpv19_7 p19_7 p19_8 20
Rgv19_7 g19_7 g19_8 200
RD19_8 p19_8 d19_8 5k
M19_8 d19_8 g19_8 0 0 nm W=10u L=1u
Rpv19_8 p19_8 p19_9 20
Rgv19_8 g19_8 g19_9 200
RD19_9 p19_9 d19_9 5k
M19_9 d19_9 g19_9 0 0 nm W=10u L=1u
Rpv19_9 p19_9 p19_10 20
Rgv19_9 g19_9 g19_10 200
RD19_10 p19_10 d19_10 5k
M19_10 d19_10 g19_10 0 0 nm W=10u L=1u
Rpv19_10 p19_10 p19_11 20
Rgv19_10 g19_10 g19_11 200
RD19_11 p19_11 d19_11 5k
M19_11 d19_11 g19_11 0 0 nm W=10u L=1u
Rpv19_11 p19_11 p19_12 20
Rgv19_11 g19_11 g19_12 200
RD19_12 p19_12 d19_12 5k
M19_12 d19_12 g19_12 0 0 nm W=10u L=1u
Rpv19_12 p19_12 p19_13 20
Rgv19_12 g19_12 g19_13 200
RD19_13 p19_13 d19_13 5k
M19_13 d19_13 g19_13 0 0 nm W=10u L=1u
Rpv19_13 p19_13 p19_14 20
Rgv19_13 g19_13 g19_14 200
RD19_14 p19_14 d19_14 5k
M19_14 d19_14 g19_14 0 0 nm W=10u L=1u
Rpv19_14 p19_14 p19_15 20
Rgv19_14 g19_14 g19_15 200
RD19_15 p19_15 d19_15 5k
M19_15 d19_15 g19_15 0 0 nm W=10u L=1u
Rpv19_15 p19_15 p19_16 20
Rgv19_15 g19_15 g19_16 200
RD19_16 p19_16 d19_16 5k
M19_16 d19_16 g19_16 0 0 nm W=10u L=1u
Rpv19_16 p19_16 p19_17 20
Rgv19_16 g19_16 g19_17 200
RD19_17 p19_17 d19_17 5k
M19_17 d19_17 g19_17 0 0 nm W=10u L=1u
Rpv19_17 p19_17 p19_18 20
Rgv19_17 g19_17 g19_18 200
RD19_18 p19_18 d19_18 5k
M19_18 d19_18 g19_18 0 0 nm W=10u L=1u
Rpv19_18 p19_18 p19_19 20
Rgv19_18 g19_18 g19_19 200
RD19_19 p19_19 d19_19 5k
M19_19 d19_19 g19_19 0 0 nm W=10u L=1u
.op
.end
