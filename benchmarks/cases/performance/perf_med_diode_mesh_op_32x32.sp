Diode-resistor mesh 32x32, one operating point
* bench.id: perf_med_diode_mesh_op_32x32
* bench.group: performance
* bench.title: Diode-resistor mesh 32x32, one operating point
* bench.probes: v(n0_0), v(n16_16), v(n31_31), i(v1)
* bench.tol.rel: 1e-6
* bench.tol.abs: 1e-9
* bench.expect: match
* bench.known_gap: faer-nonlinear-slow
* bench.gap.note: solved on the faer supernodal tier (symbolic setup plus one factorisation per Newton iteration), which is slower than ngspice KLU on this nonlinear 2-D mesh
* bench.ng.solver: both
* bench.timing: yes
* bench.size: 1026
* bench.est_rss_mib: 35
* bench.tags: nonlinear, op, mesh, diode, medium, faer_tier
* bench.note: 1026 unknowns with 2-D fill and one exponential device per node: symbolic setup and the factorisation of every Newton iteration dominate
.model dm D(IS=1e-14 N=1)
V1 in 0 3
Rin in n0_0 100
D0_0 n0_0 0 dm
Rh0_0 n0_0 n0_1 100
Rv0_0 n0_0 n1_0 100
D0_1 n0_1 0 dm
Rh0_1 n0_1 n0_2 100
Rv0_1 n0_1 n1_1 100
D0_2 n0_2 0 dm
Rh0_2 n0_2 n0_3 100
Rv0_2 n0_2 n1_2 100
D0_3 n0_3 0 dm
Rh0_3 n0_3 n0_4 100
Rv0_3 n0_3 n1_3 100
D0_4 n0_4 0 dm
Rh0_4 n0_4 n0_5 100
Rv0_4 n0_4 n1_4 100
D0_5 n0_5 0 dm
Rh0_5 n0_5 n0_6 100
Rv0_5 n0_5 n1_5 100
D0_6 n0_6 0 dm
Rh0_6 n0_6 n0_7 100
Rv0_6 n0_6 n1_6 100
D0_7 n0_7 0 dm
Rh0_7 n0_7 n0_8 100
Rv0_7 n0_7 n1_7 100
D0_8 n0_8 0 dm
Rh0_8 n0_8 n0_9 100
Rv0_8 n0_8 n1_8 100
D0_9 n0_9 0 dm
Rh0_9 n0_9 n0_10 100
Rv0_9 n0_9 n1_9 100
D0_10 n0_10 0 dm
Rh0_10 n0_10 n0_11 100
Rv0_10 n0_10 n1_10 100
D0_11 n0_11 0 dm
Rh0_11 n0_11 n0_12 100
Rv0_11 n0_11 n1_11 100
D0_12 n0_12 0 dm
Rh0_12 n0_12 n0_13 100
Rv0_12 n0_12 n1_12 100
D0_13 n0_13 0 dm
Rh0_13 n0_13 n0_14 100
Rv0_13 n0_13 n1_13 100
D0_14 n0_14 0 dm
Rh0_14 n0_14 n0_15 100
Rv0_14 n0_14 n1_14 100
D0_15 n0_15 0 dm
Rh0_15 n0_15 n0_16 100
Rv0_15 n0_15 n1_15 100
D0_16 n0_16 0 dm
Rh0_16 n0_16 n0_17 100
Rv0_16 n0_16 n1_16 100
D0_17 n0_17 0 dm
Rh0_17 n0_17 n0_18 100
Rv0_17 n0_17 n1_17 100
D0_18 n0_18 0 dm
Rh0_18 n0_18 n0_19 100
Rv0_18 n0_18 n1_18 100
D0_19 n0_19 0 dm
Rh0_19 n0_19 n0_20 100
Rv0_19 n0_19 n1_19 100
D0_20 n0_20 0 dm
Rh0_20 n0_20 n0_21 100
Rv0_20 n0_20 n1_20 100
D0_21 n0_21 0 dm
Rh0_21 n0_21 n0_22 100
Rv0_21 n0_21 n1_21 100
D0_22 n0_22 0 dm
Rh0_22 n0_22 n0_23 100
Rv0_22 n0_22 n1_22 100
D0_23 n0_23 0 dm
Rh0_23 n0_23 n0_24 100
Rv0_23 n0_23 n1_23 100
D0_24 n0_24 0 dm
Rh0_24 n0_24 n0_25 100
Rv0_24 n0_24 n1_24 100
D0_25 n0_25 0 dm
Rh0_25 n0_25 n0_26 100
Rv0_25 n0_25 n1_25 100
D0_26 n0_26 0 dm
Rh0_26 n0_26 n0_27 100
Rv0_26 n0_26 n1_26 100
D0_27 n0_27 0 dm
Rh0_27 n0_27 n0_28 100
Rv0_27 n0_27 n1_27 100
D0_28 n0_28 0 dm
Rh0_28 n0_28 n0_29 100
Rv0_28 n0_28 n1_28 100
D0_29 n0_29 0 dm
Rh0_29 n0_29 n0_30 100
Rv0_29 n0_29 n1_29 100
D0_30 n0_30 0 dm
Rh0_30 n0_30 n0_31 100
Rv0_30 n0_30 n1_30 100
D0_31 n0_31 0 dm
Rv0_31 n0_31 n1_31 100
D1_0 n1_0 0 dm
Rh1_0 n1_0 n1_1 100
Rv1_0 n1_0 n2_0 100
D1_1 n1_1 0 dm
Rh1_1 n1_1 n1_2 100
Rv1_1 n1_1 n2_1 100
D1_2 n1_2 0 dm
Rh1_2 n1_2 n1_3 100
Rv1_2 n1_2 n2_2 100
D1_3 n1_3 0 dm
Rh1_3 n1_3 n1_4 100
Rv1_3 n1_3 n2_3 100
D1_4 n1_4 0 dm
Rh1_4 n1_4 n1_5 100
Rv1_4 n1_4 n2_4 100
D1_5 n1_5 0 dm
Rh1_5 n1_5 n1_6 100
Rv1_5 n1_5 n2_5 100
D1_6 n1_6 0 dm
Rh1_6 n1_6 n1_7 100
Rv1_6 n1_6 n2_6 100
D1_7 n1_7 0 dm
Rh1_7 n1_7 n1_8 100
Rv1_7 n1_7 n2_7 100
D1_8 n1_8 0 dm
Rh1_8 n1_8 n1_9 100
Rv1_8 n1_8 n2_8 100
D1_9 n1_9 0 dm
Rh1_9 n1_9 n1_10 100
Rv1_9 n1_9 n2_9 100
D1_10 n1_10 0 dm
Rh1_10 n1_10 n1_11 100
Rv1_10 n1_10 n2_10 100
D1_11 n1_11 0 dm
Rh1_11 n1_11 n1_12 100
Rv1_11 n1_11 n2_11 100
D1_12 n1_12 0 dm
Rh1_12 n1_12 n1_13 100
Rv1_12 n1_12 n2_12 100
D1_13 n1_13 0 dm
Rh1_13 n1_13 n1_14 100
Rv1_13 n1_13 n2_13 100
D1_14 n1_14 0 dm
Rh1_14 n1_14 n1_15 100
Rv1_14 n1_14 n2_14 100
D1_15 n1_15 0 dm
Rh1_15 n1_15 n1_16 100
Rv1_15 n1_15 n2_15 100
D1_16 n1_16 0 dm
Rh1_16 n1_16 n1_17 100
Rv1_16 n1_16 n2_16 100
D1_17 n1_17 0 dm
Rh1_17 n1_17 n1_18 100
Rv1_17 n1_17 n2_17 100
D1_18 n1_18 0 dm
Rh1_18 n1_18 n1_19 100
Rv1_18 n1_18 n2_18 100
D1_19 n1_19 0 dm
Rh1_19 n1_19 n1_20 100
Rv1_19 n1_19 n2_19 100
D1_20 n1_20 0 dm
Rh1_20 n1_20 n1_21 100
Rv1_20 n1_20 n2_20 100
D1_21 n1_21 0 dm
Rh1_21 n1_21 n1_22 100
Rv1_21 n1_21 n2_21 100
D1_22 n1_22 0 dm
Rh1_22 n1_22 n1_23 100
Rv1_22 n1_22 n2_22 100
D1_23 n1_23 0 dm
Rh1_23 n1_23 n1_24 100
Rv1_23 n1_23 n2_23 100
D1_24 n1_24 0 dm
Rh1_24 n1_24 n1_25 100
Rv1_24 n1_24 n2_24 100
D1_25 n1_25 0 dm
Rh1_25 n1_25 n1_26 100
Rv1_25 n1_25 n2_25 100
D1_26 n1_26 0 dm
Rh1_26 n1_26 n1_27 100
Rv1_26 n1_26 n2_26 100
D1_27 n1_27 0 dm
Rh1_27 n1_27 n1_28 100
Rv1_27 n1_27 n2_27 100
D1_28 n1_28 0 dm
Rh1_28 n1_28 n1_29 100
Rv1_28 n1_28 n2_28 100
D1_29 n1_29 0 dm
Rh1_29 n1_29 n1_30 100
Rv1_29 n1_29 n2_29 100
D1_30 n1_30 0 dm
Rh1_30 n1_30 n1_31 100
Rv1_30 n1_30 n2_30 100
D1_31 n1_31 0 dm
Rv1_31 n1_31 n2_31 100
D2_0 n2_0 0 dm
Rh2_0 n2_0 n2_1 100
Rv2_0 n2_0 n3_0 100
D2_1 n2_1 0 dm
Rh2_1 n2_1 n2_2 100
Rv2_1 n2_1 n3_1 100
D2_2 n2_2 0 dm
Rh2_2 n2_2 n2_3 100
Rv2_2 n2_2 n3_2 100
D2_3 n2_3 0 dm
Rh2_3 n2_3 n2_4 100
Rv2_3 n2_3 n3_3 100
D2_4 n2_4 0 dm
Rh2_4 n2_4 n2_5 100
Rv2_4 n2_4 n3_4 100
D2_5 n2_5 0 dm
Rh2_5 n2_5 n2_6 100
Rv2_5 n2_5 n3_5 100
D2_6 n2_6 0 dm
Rh2_6 n2_6 n2_7 100
Rv2_6 n2_6 n3_6 100
D2_7 n2_7 0 dm
Rh2_7 n2_7 n2_8 100
Rv2_7 n2_7 n3_7 100
D2_8 n2_8 0 dm
Rh2_8 n2_8 n2_9 100
Rv2_8 n2_8 n3_8 100
D2_9 n2_9 0 dm
Rh2_9 n2_9 n2_10 100
Rv2_9 n2_9 n3_9 100
D2_10 n2_10 0 dm
Rh2_10 n2_10 n2_11 100
Rv2_10 n2_10 n3_10 100
D2_11 n2_11 0 dm
Rh2_11 n2_11 n2_12 100
Rv2_11 n2_11 n3_11 100
D2_12 n2_12 0 dm
Rh2_12 n2_12 n2_13 100
Rv2_12 n2_12 n3_12 100
D2_13 n2_13 0 dm
Rh2_13 n2_13 n2_14 100
Rv2_13 n2_13 n3_13 100
D2_14 n2_14 0 dm
Rh2_14 n2_14 n2_15 100
Rv2_14 n2_14 n3_14 100
D2_15 n2_15 0 dm
Rh2_15 n2_15 n2_16 100
Rv2_15 n2_15 n3_15 100
D2_16 n2_16 0 dm
Rh2_16 n2_16 n2_17 100
Rv2_16 n2_16 n3_16 100
D2_17 n2_17 0 dm
Rh2_17 n2_17 n2_18 100
Rv2_17 n2_17 n3_17 100
D2_18 n2_18 0 dm
Rh2_18 n2_18 n2_19 100
Rv2_18 n2_18 n3_18 100
D2_19 n2_19 0 dm
Rh2_19 n2_19 n2_20 100
Rv2_19 n2_19 n3_19 100
D2_20 n2_20 0 dm
Rh2_20 n2_20 n2_21 100
Rv2_20 n2_20 n3_20 100
D2_21 n2_21 0 dm
Rh2_21 n2_21 n2_22 100
Rv2_21 n2_21 n3_21 100
D2_22 n2_22 0 dm
Rh2_22 n2_22 n2_23 100
Rv2_22 n2_22 n3_22 100
D2_23 n2_23 0 dm
Rh2_23 n2_23 n2_24 100
Rv2_23 n2_23 n3_23 100
D2_24 n2_24 0 dm
Rh2_24 n2_24 n2_25 100
Rv2_24 n2_24 n3_24 100
D2_25 n2_25 0 dm
Rh2_25 n2_25 n2_26 100
Rv2_25 n2_25 n3_25 100
D2_26 n2_26 0 dm
Rh2_26 n2_26 n2_27 100
Rv2_26 n2_26 n3_26 100
D2_27 n2_27 0 dm
Rh2_27 n2_27 n2_28 100
Rv2_27 n2_27 n3_27 100
D2_28 n2_28 0 dm
Rh2_28 n2_28 n2_29 100
Rv2_28 n2_28 n3_28 100
D2_29 n2_29 0 dm
Rh2_29 n2_29 n2_30 100
Rv2_29 n2_29 n3_29 100
D2_30 n2_30 0 dm
Rh2_30 n2_30 n2_31 100
Rv2_30 n2_30 n3_30 100
D2_31 n2_31 0 dm
Rv2_31 n2_31 n3_31 100
D3_0 n3_0 0 dm
Rh3_0 n3_0 n3_1 100
Rv3_0 n3_0 n4_0 100
D3_1 n3_1 0 dm
Rh3_1 n3_1 n3_2 100
Rv3_1 n3_1 n4_1 100
D3_2 n3_2 0 dm
Rh3_2 n3_2 n3_3 100
Rv3_2 n3_2 n4_2 100
D3_3 n3_3 0 dm
Rh3_3 n3_3 n3_4 100
Rv3_3 n3_3 n4_3 100
D3_4 n3_4 0 dm
Rh3_4 n3_4 n3_5 100
Rv3_4 n3_4 n4_4 100
D3_5 n3_5 0 dm
Rh3_5 n3_5 n3_6 100
Rv3_5 n3_5 n4_5 100
D3_6 n3_6 0 dm
Rh3_6 n3_6 n3_7 100
Rv3_6 n3_6 n4_6 100
D3_7 n3_7 0 dm
Rh3_7 n3_7 n3_8 100
Rv3_7 n3_7 n4_7 100
D3_8 n3_8 0 dm
Rh3_8 n3_8 n3_9 100
Rv3_8 n3_8 n4_8 100
D3_9 n3_9 0 dm
Rh3_9 n3_9 n3_10 100
Rv3_9 n3_9 n4_9 100
D3_10 n3_10 0 dm
Rh3_10 n3_10 n3_11 100
Rv3_10 n3_10 n4_10 100
D3_11 n3_11 0 dm
Rh3_11 n3_11 n3_12 100
Rv3_11 n3_11 n4_11 100
D3_12 n3_12 0 dm
Rh3_12 n3_12 n3_13 100
Rv3_12 n3_12 n4_12 100
D3_13 n3_13 0 dm
Rh3_13 n3_13 n3_14 100
Rv3_13 n3_13 n4_13 100
D3_14 n3_14 0 dm
Rh3_14 n3_14 n3_15 100
Rv3_14 n3_14 n4_14 100
D3_15 n3_15 0 dm
Rh3_15 n3_15 n3_16 100
Rv3_15 n3_15 n4_15 100
D3_16 n3_16 0 dm
Rh3_16 n3_16 n3_17 100
Rv3_16 n3_16 n4_16 100
D3_17 n3_17 0 dm
Rh3_17 n3_17 n3_18 100
Rv3_17 n3_17 n4_17 100
D3_18 n3_18 0 dm
Rh3_18 n3_18 n3_19 100
Rv3_18 n3_18 n4_18 100
D3_19 n3_19 0 dm
Rh3_19 n3_19 n3_20 100
Rv3_19 n3_19 n4_19 100
D3_20 n3_20 0 dm
Rh3_20 n3_20 n3_21 100
Rv3_20 n3_20 n4_20 100
D3_21 n3_21 0 dm
Rh3_21 n3_21 n3_22 100
Rv3_21 n3_21 n4_21 100
D3_22 n3_22 0 dm
Rh3_22 n3_22 n3_23 100
Rv3_22 n3_22 n4_22 100
D3_23 n3_23 0 dm
Rh3_23 n3_23 n3_24 100
Rv3_23 n3_23 n4_23 100
D3_24 n3_24 0 dm
Rh3_24 n3_24 n3_25 100
Rv3_24 n3_24 n4_24 100
D3_25 n3_25 0 dm
Rh3_25 n3_25 n3_26 100
Rv3_25 n3_25 n4_25 100
D3_26 n3_26 0 dm
Rh3_26 n3_26 n3_27 100
Rv3_26 n3_26 n4_26 100
D3_27 n3_27 0 dm
Rh3_27 n3_27 n3_28 100
Rv3_27 n3_27 n4_27 100
D3_28 n3_28 0 dm
Rh3_28 n3_28 n3_29 100
Rv3_28 n3_28 n4_28 100
D3_29 n3_29 0 dm
Rh3_29 n3_29 n3_30 100
Rv3_29 n3_29 n4_29 100
D3_30 n3_30 0 dm
Rh3_30 n3_30 n3_31 100
Rv3_30 n3_30 n4_30 100
D3_31 n3_31 0 dm
Rv3_31 n3_31 n4_31 100
D4_0 n4_0 0 dm
Rh4_0 n4_0 n4_1 100
Rv4_0 n4_0 n5_0 100
D4_1 n4_1 0 dm
Rh4_1 n4_1 n4_2 100
Rv4_1 n4_1 n5_1 100
D4_2 n4_2 0 dm
Rh4_2 n4_2 n4_3 100
Rv4_2 n4_2 n5_2 100
D4_3 n4_3 0 dm
Rh4_3 n4_3 n4_4 100
Rv4_3 n4_3 n5_3 100
D4_4 n4_4 0 dm
Rh4_4 n4_4 n4_5 100
Rv4_4 n4_4 n5_4 100
D4_5 n4_5 0 dm
Rh4_5 n4_5 n4_6 100
Rv4_5 n4_5 n5_5 100
D4_6 n4_6 0 dm
Rh4_6 n4_6 n4_7 100
Rv4_6 n4_6 n5_6 100
D4_7 n4_7 0 dm
Rh4_7 n4_7 n4_8 100
Rv4_7 n4_7 n5_7 100
D4_8 n4_8 0 dm
Rh4_8 n4_8 n4_9 100
Rv4_8 n4_8 n5_8 100
D4_9 n4_9 0 dm
Rh4_9 n4_9 n4_10 100
Rv4_9 n4_9 n5_9 100
D4_10 n4_10 0 dm
Rh4_10 n4_10 n4_11 100
Rv4_10 n4_10 n5_10 100
D4_11 n4_11 0 dm
Rh4_11 n4_11 n4_12 100
Rv4_11 n4_11 n5_11 100
D4_12 n4_12 0 dm
Rh4_12 n4_12 n4_13 100
Rv4_12 n4_12 n5_12 100
D4_13 n4_13 0 dm
Rh4_13 n4_13 n4_14 100
Rv4_13 n4_13 n5_13 100
D4_14 n4_14 0 dm
Rh4_14 n4_14 n4_15 100
Rv4_14 n4_14 n5_14 100
D4_15 n4_15 0 dm
Rh4_15 n4_15 n4_16 100
Rv4_15 n4_15 n5_15 100
D4_16 n4_16 0 dm
Rh4_16 n4_16 n4_17 100
Rv4_16 n4_16 n5_16 100
D4_17 n4_17 0 dm
Rh4_17 n4_17 n4_18 100
Rv4_17 n4_17 n5_17 100
D4_18 n4_18 0 dm
Rh4_18 n4_18 n4_19 100
Rv4_18 n4_18 n5_18 100
D4_19 n4_19 0 dm
Rh4_19 n4_19 n4_20 100
Rv4_19 n4_19 n5_19 100
D4_20 n4_20 0 dm
Rh4_20 n4_20 n4_21 100
Rv4_20 n4_20 n5_20 100
D4_21 n4_21 0 dm
Rh4_21 n4_21 n4_22 100
Rv4_21 n4_21 n5_21 100
D4_22 n4_22 0 dm
Rh4_22 n4_22 n4_23 100
Rv4_22 n4_22 n5_22 100
D4_23 n4_23 0 dm
Rh4_23 n4_23 n4_24 100
Rv4_23 n4_23 n5_23 100
D4_24 n4_24 0 dm
Rh4_24 n4_24 n4_25 100
Rv4_24 n4_24 n5_24 100
D4_25 n4_25 0 dm
Rh4_25 n4_25 n4_26 100
Rv4_25 n4_25 n5_25 100
D4_26 n4_26 0 dm
Rh4_26 n4_26 n4_27 100
Rv4_26 n4_26 n5_26 100
D4_27 n4_27 0 dm
Rh4_27 n4_27 n4_28 100
Rv4_27 n4_27 n5_27 100
D4_28 n4_28 0 dm
Rh4_28 n4_28 n4_29 100
Rv4_28 n4_28 n5_28 100
D4_29 n4_29 0 dm
Rh4_29 n4_29 n4_30 100
Rv4_29 n4_29 n5_29 100
D4_30 n4_30 0 dm
Rh4_30 n4_30 n4_31 100
Rv4_30 n4_30 n5_30 100
D4_31 n4_31 0 dm
Rv4_31 n4_31 n5_31 100
D5_0 n5_0 0 dm
Rh5_0 n5_0 n5_1 100
Rv5_0 n5_0 n6_0 100
D5_1 n5_1 0 dm
Rh5_1 n5_1 n5_2 100
Rv5_1 n5_1 n6_1 100
D5_2 n5_2 0 dm
Rh5_2 n5_2 n5_3 100
Rv5_2 n5_2 n6_2 100
D5_3 n5_3 0 dm
Rh5_3 n5_3 n5_4 100
Rv5_3 n5_3 n6_3 100
D5_4 n5_4 0 dm
Rh5_4 n5_4 n5_5 100
Rv5_4 n5_4 n6_4 100
D5_5 n5_5 0 dm
Rh5_5 n5_5 n5_6 100
Rv5_5 n5_5 n6_5 100
D5_6 n5_6 0 dm
Rh5_6 n5_6 n5_7 100
Rv5_6 n5_6 n6_6 100
D5_7 n5_7 0 dm
Rh5_7 n5_7 n5_8 100
Rv5_7 n5_7 n6_7 100
D5_8 n5_8 0 dm
Rh5_8 n5_8 n5_9 100
Rv5_8 n5_8 n6_8 100
D5_9 n5_9 0 dm
Rh5_9 n5_9 n5_10 100
Rv5_9 n5_9 n6_9 100
D5_10 n5_10 0 dm
Rh5_10 n5_10 n5_11 100
Rv5_10 n5_10 n6_10 100
D5_11 n5_11 0 dm
Rh5_11 n5_11 n5_12 100
Rv5_11 n5_11 n6_11 100
D5_12 n5_12 0 dm
Rh5_12 n5_12 n5_13 100
Rv5_12 n5_12 n6_12 100
D5_13 n5_13 0 dm
Rh5_13 n5_13 n5_14 100
Rv5_13 n5_13 n6_13 100
D5_14 n5_14 0 dm
Rh5_14 n5_14 n5_15 100
Rv5_14 n5_14 n6_14 100
D5_15 n5_15 0 dm
Rh5_15 n5_15 n5_16 100
Rv5_15 n5_15 n6_15 100
D5_16 n5_16 0 dm
Rh5_16 n5_16 n5_17 100
Rv5_16 n5_16 n6_16 100
D5_17 n5_17 0 dm
Rh5_17 n5_17 n5_18 100
Rv5_17 n5_17 n6_17 100
D5_18 n5_18 0 dm
Rh5_18 n5_18 n5_19 100
Rv5_18 n5_18 n6_18 100
D5_19 n5_19 0 dm
Rh5_19 n5_19 n5_20 100
Rv5_19 n5_19 n6_19 100
D5_20 n5_20 0 dm
Rh5_20 n5_20 n5_21 100
Rv5_20 n5_20 n6_20 100
D5_21 n5_21 0 dm
Rh5_21 n5_21 n5_22 100
Rv5_21 n5_21 n6_21 100
D5_22 n5_22 0 dm
Rh5_22 n5_22 n5_23 100
Rv5_22 n5_22 n6_22 100
D5_23 n5_23 0 dm
Rh5_23 n5_23 n5_24 100
Rv5_23 n5_23 n6_23 100
D5_24 n5_24 0 dm
Rh5_24 n5_24 n5_25 100
Rv5_24 n5_24 n6_24 100
D5_25 n5_25 0 dm
Rh5_25 n5_25 n5_26 100
Rv5_25 n5_25 n6_25 100
D5_26 n5_26 0 dm
Rh5_26 n5_26 n5_27 100
Rv5_26 n5_26 n6_26 100
D5_27 n5_27 0 dm
Rh5_27 n5_27 n5_28 100
Rv5_27 n5_27 n6_27 100
D5_28 n5_28 0 dm
Rh5_28 n5_28 n5_29 100
Rv5_28 n5_28 n6_28 100
D5_29 n5_29 0 dm
Rh5_29 n5_29 n5_30 100
Rv5_29 n5_29 n6_29 100
D5_30 n5_30 0 dm
Rh5_30 n5_30 n5_31 100
Rv5_30 n5_30 n6_30 100
D5_31 n5_31 0 dm
Rv5_31 n5_31 n6_31 100
D6_0 n6_0 0 dm
Rh6_0 n6_0 n6_1 100
Rv6_0 n6_0 n7_0 100
D6_1 n6_1 0 dm
Rh6_1 n6_1 n6_2 100
Rv6_1 n6_1 n7_1 100
D6_2 n6_2 0 dm
Rh6_2 n6_2 n6_3 100
Rv6_2 n6_2 n7_2 100
D6_3 n6_3 0 dm
Rh6_3 n6_3 n6_4 100
Rv6_3 n6_3 n7_3 100
D6_4 n6_4 0 dm
Rh6_4 n6_4 n6_5 100
Rv6_4 n6_4 n7_4 100
D6_5 n6_5 0 dm
Rh6_5 n6_5 n6_6 100
Rv6_5 n6_5 n7_5 100
D6_6 n6_6 0 dm
Rh6_6 n6_6 n6_7 100
Rv6_6 n6_6 n7_6 100
D6_7 n6_7 0 dm
Rh6_7 n6_7 n6_8 100
Rv6_7 n6_7 n7_7 100
D6_8 n6_8 0 dm
Rh6_8 n6_8 n6_9 100
Rv6_8 n6_8 n7_8 100
D6_9 n6_9 0 dm
Rh6_9 n6_9 n6_10 100
Rv6_9 n6_9 n7_9 100
D6_10 n6_10 0 dm
Rh6_10 n6_10 n6_11 100
Rv6_10 n6_10 n7_10 100
D6_11 n6_11 0 dm
Rh6_11 n6_11 n6_12 100
Rv6_11 n6_11 n7_11 100
D6_12 n6_12 0 dm
Rh6_12 n6_12 n6_13 100
Rv6_12 n6_12 n7_12 100
D6_13 n6_13 0 dm
Rh6_13 n6_13 n6_14 100
Rv6_13 n6_13 n7_13 100
D6_14 n6_14 0 dm
Rh6_14 n6_14 n6_15 100
Rv6_14 n6_14 n7_14 100
D6_15 n6_15 0 dm
Rh6_15 n6_15 n6_16 100
Rv6_15 n6_15 n7_15 100
D6_16 n6_16 0 dm
Rh6_16 n6_16 n6_17 100
Rv6_16 n6_16 n7_16 100
D6_17 n6_17 0 dm
Rh6_17 n6_17 n6_18 100
Rv6_17 n6_17 n7_17 100
D6_18 n6_18 0 dm
Rh6_18 n6_18 n6_19 100
Rv6_18 n6_18 n7_18 100
D6_19 n6_19 0 dm
Rh6_19 n6_19 n6_20 100
Rv6_19 n6_19 n7_19 100
D6_20 n6_20 0 dm
Rh6_20 n6_20 n6_21 100
Rv6_20 n6_20 n7_20 100
D6_21 n6_21 0 dm
Rh6_21 n6_21 n6_22 100
Rv6_21 n6_21 n7_21 100
D6_22 n6_22 0 dm
Rh6_22 n6_22 n6_23 100
Rv6_22 n6_22 n7_22 100
D6_23 n6_23 0 dm
Rh6_23 n6_23 n6_24 100
Rv6_23 n6_23 n7_23 100
D6_24 n6_24 0 dm
Rh6_24 n6_24 n6_25 100
Rv6_24 n6_24 n7_24 100
D6_25 n6_25 0 dm
Rh6_25 n6_25 n6_26 100
Rv6_25 n6_25 n7_25 100
D6_26 n6_26 0 dm
Rh6_26 n6_26 n6_27 100
Rv6_26 n6_26 n7_26 100
D6_27 n6_27 0 dm
Rh6_27 n6_27 n6_28 100
Rv6_27 n6_27 n7_27 100
D6_28 n6_28 0 dm
Rh6_28 n6_28 n6_29 100
Rv6_28 n6_28 n7_28 100
D6_29 n6_29 0 dm
Rh6_29 n6_29 n6_30 100
Rv6_29 n6_29 n7_29 100
D6_30 n6_30 0 dm
Rh6_30 n6_30 n6_31 100
Rv6_30 n6_30 n7_30 100
D6_31 n6_31 0 dm
Rv6_31 n6_31 n7_31 100
D7_0 n7_0 0 dm
Rh7_0 n7_0 n7_1 100
Rv7_0 n7_0 n8_0 100
D7_1 n7_1 0 dm
Rh7_1 n7_1 n7_2 100
Rv7_1 n7_1 n8_1 100
D7_2 n7_2 0 dm
Rh7_2 n7_2 n7_3 100
Rv7_2 n7_2 n8_2 100
D7_3 n7_3 0 dm
Rh7_3 n7_3 n7_4 100
Rv7_3 n7_3 n8_3 100
D7_4 n7_4 0 dm
Rh7_4 n7_4 n7_5 100
Rv7_4 n7_4 n8_4 100
D7_5 n7_5 0 dm
Rh7_5 n7_5 n7_6 100
Rv7_5 n7_5 n8_5 100
D7_6 n7_6 0 dm
Rh7_6 n7_6 n7_7 100
Rv7_6 n7_6 n8_6 100
D7_7 n7_7 0 dm
Rh7_7 n7_7 n7_8 100
Rv7_7 n7_7 n8_7 100
D7_8 n7_8 0 dm
Rh7_8 n7_8 n7_9 100
Rv7_8 n7_8 n8_8 100
D7_9 n7_9 0 dm
Rh7_9 n7_9 n7_10 100
Rv7_9 n7_9 n8_9 100
D7_10 n7_10 0 dm
Rh7_10 n7_10 n7_11 100
Rv7_10 n7_10 n8_10 100
D7_11 n7_11 0 dm
Rh7_11 n7_11 n7_12 100
Rv7_11 n7_11 n8_11 100
D7_12 n7_12 0 dm
Rh7_12 n7_12 n7_13 100
Rv7_12 n7_12 n8_12 100
D7_13 n7_13 0 dm
Rh7_13 n7_13 n7_14 100
Rv7_13 n7_13 n8_13 100
D7_14 n7_14 0 dm
Rh7_14 n7_14 n7_15 100
Rv7_14 n7_14 n8_14 100
D7_15 n7_15 0 dm
Rh7_15 n7_15 n7_16 100
Rv7_15 n7_15 n8_15 100
D7_16 n7_16 0 dm
Rh7_16 n7_16 n7_17 100
Rv7_16 n7_16 n8_16 100
D7_17 n7_17 0 dm
Rh7_17 n7_17 n7_18 100
Rv7_17 n7_17 n8_17 100
D7_18 n7_18 0 dm
Rh7_18 n7_18 n7_19 100
Rv7_18 n7_18 n8_18 100
D7_19 n7_19 0 dm
Rh7_19 n7_19 n7_20 100
Rv7_19 n7_19 n8_19 100
D7_20 n7_20 0 dm
Rh7_20 n7_20 n7_21 100
Rv7_20 n7_20 n8_20 100
D7_21 n7_21 0 dm
Rh7_21 n7_21 n7_22 100
Rv7_21 n7_21 n8_21 100
D7_22 n7_22 0 dm
Rh7_22 n7_22 n7_23 100
Rv7_22 n7_22 n8_22 100
D7_23 n7_23 0 dm
Rh7_23 n7_23 n7_24 100
Rv7_23 n7_23 n8_23 100
D7_24 n7_24 0 dm
Rh7_24 n7_24 n7_25 100
Rv7_24 n7_24 n8_24 100
D7_25 n7_25 0 dm
Rh7_25 n7_25 n7_26 100
Rv7_25 n7_25 n8_25 100
D7_26 n7_26 0 dm
Rh7_26 n7_26 n7_27 100
Rv7_26 n7_26 n8_26 100
D7_27 n7_27 0 dm
Rh7_27 n7_27 n7_28 100
Rv7_27 n7_27 n8_27 100
D7_28 n7_28 0 dm
Rh7_28 n7_28 n7_29 100
Rv7_28 n7_28 n8_28 100
D7_29 n7_29 0 dm
Rh7_29 n7_29 n7_30 100
Rv7_29 n7_29 n8_29 100
D7_30 n7_30 0 dm
Rh7_30 n7_30 n7_31 100
Rv7_30 n7_30 n8_30 100
D7_31 n7_31 0 dm
Rv7_31 n7_31 n8_31 100
D8_0 n8_0 0 dm
Rh8_0 n8_0 n8_1 100
Rv8_0 n8_0 n9_0 100
D8_1 n8_1 0 dm
Rh8_1 n8_1 n8_2 100
Rv8_1 n8_1 n9_1 100
D8_2 n8_2 0 dm
Rh8_2 n8_2 n8_3 100
Rv8_2 n8_2 n9_2 100
D8_3 n8_3 0 dm
Rh8_3 n8_3 n8_4 100
Rv8_3 n8_3 n9_3 100
D8_4 n8_4 0 dm
Rh8_4 n8_4 n8_5 100
Rv8_4 n8_4 n9_4 100
D8_5 n8_5 0 dm
Rh8_5 n8_5 n8_6 100
Rv8_5 n8_5 n9_5 100
D8_6 n8_6 0 dm
Rh8_6 n8_6 n8_7 100
Rv8_6 n8_6 n9_6 100
D8_7 n8_7 0 dm
Rh8_7 n8_7 n8_8 100
Rv8_7 n8_7 n9_7 100
D8_8 n8_8 0 dm
Rh8_8 n8_8 n8_9 100
Rv8_8 n8_8 n9_8 100
D8_9 n8_9 0 dm
Rh8_9 n8_9 n8_10 100
Rv8_9 n8_9 n9_9 100
D8_10 n8_10 0 dm
Rh8_10 n8_10 n8_11 100
Rv8_10 n8_10 n9_10 100
D8_11 n8_11 0 dm
Rh8_11 n8_11 n8_12 100
Rv8_11 n8_11 n9_11 100
D8_12 n8_12 0 dm
Rh8_12 n8_12 n8_13 100
Rv8_12 n8_12 n9_12 100
D8_13 n8_13 0 dm
Rh8_13 n8_13 n8_14 100
Rv8_13 n8_13 n9_13 100
D8_14 n8_14 0 dm
Rh8_14 n8_14 n8_15 100
Rv8_14 n8_14 n9_14 100
D8_15 n8_15 0 dm
Rh8_15 n8_15 n8_16 100
Rv8_15 n8_15 n9_15 100
D8_16 n8_16 0 dm
Rh8_16 n8_16 n8_17 100
Rv8_16 n8_16 n9_16 100
D8_17 n8_17 0 dm
Rh8_17 n8_17 n8_18 100
Rv8_17 n8_17 n9_17 100
D8_18 n8_18 0 dm
Rh8_18 n8_18 n8_19 100
Rv8_18 n8_18 n9_18 100
D8_19 n8_19 0 dm
Rh8_19 n8_19 n8_20 100
Rv8_19 n8_19 n9_19 100
D8_20 n8_20 0 dm
Rh8_20 n8_20 n8_21 100
Rv8_20 n8_20 n9_20 100
D8_21 n8_21 0 dm
Rh8_21 n8_21 n8_22 100
Rv8_21 n8_21 n9_21 100
D8_22 n8_22 0 dm
Rh8_22 n8_22 n8_23 100
Rv8_22 n8_22 n9_22 100
D8_23 n8_23 0 dm
Rh8_23 n8_23 n8_24 100
Rv8_23 n8_23 n9_23 100
D8_24 n8_24 0 dm
Rh8_24 n8_24 n8_25 100
Rv8_24 n8_24 n9_24 100
D8_25 n8_25 0 dm
Rh8_25 n8_25 n8_26 100
Rv8_25 n8_25 n9_25 100
D8_26 n8_26 0 dm
Rh8_26 n8_26 n8_27 100
Rv8_26 n8_26 n9_26 100
D8_27 n8_27 0 dm
Rh8_27 n8_27 n8_28 100
Rv8_27 n8_27 n9_27 100
D8_28 n8_28 0 dm
Rh8_28 n8_28 n8_29 100
Rv8_28 n8_28 n9_28 100
D8_29 n8_29 0 dm
Rh8_29 n8_29 n8_30 100
Rv8_29 n8_29 n9_29 100
D8_30 n8_30 0 dm
Rh8_30 n8_30 n8_31 100
Rv8_30 n8_30 n9_30 100
D8_31 n8_31 0 dm
Rv8_31 n8_31 n9_31 100
D9_0 n9_0 0 dm
Rh9_0 n9_0 n9_1 100
Rv9_0 n9_0 n10_0 100
D9_1 n9_1 0 dm
Rh9_1 n9_1 n9_2 100
Rv9_1 n9_1 n10_1 100
D9_2 n9_2 0 dm
Rh9_2 n9_2 n9_3 100
Rv9_2 n9_2 n10_2 100
D9_3 n9_3 0 dm
Rh9_3 n9_3 n9_4 100
Rv9_3 n9_3 n10_3 100
D9_4 n9_4 0 dm
Rh9_4 n9_4 n9_5 100
Rv9_4 n9_4 n10_4 100
D9_5 n9_5 0 dm
Rh9_5 n9_5 n9_6 100
Rv9_5 n9_5 n10_5 100
D9_6 n9_6 0 dm
Rh9_6 n9_6 n9_7 100
Rv9_6 n9_6 n10_6 100
D9_7 n9_7 0 dm
Rh9_7 n9_7 n9_8 100
Rv9_7 n9_7 n10_7 100
D9_8 n9_8 0 dm
Rh9_8 n9_8 n9_9 100
Rv9_8 n9_8 n10_8 100
D9_9 n9_9 0 dm
Rh9_9 n9_9 n9_10 100
Rv9_9 n9_9 n10_9 100
D9_10 n9_10 0 dm
Rh9_10 n9_10 n9_11 100
Rv9_10 n9_10 n10_10 100
D9_11 n9_11 0 dm
Rh9_11 n9_11 n9_12 100
Rv9_11 n9_11 n10_11 100
D9_12 n9_12 0 dm
Rh9_12 n9_12 n9_13 100
Rv9_12 n9_12 n10_12 100
D9_13 n9_13 0 dm
Rh9_13 n9_13 n9_14 100
Rv9_13 n9_13 n10_13 100
D9_14 n9_14 0 dm
Rh9_14 n9_14 n9_15 100
Rv9_14 n9_14 n10_14 100
D9_15 n9_15 0 dm
Rh9_15 n9_15 n9_16 100
Rv9_15 n9_15 n10_15 100
D9_16 n9_16 0 dm
Rh9_16 n9_16 n9_17 100
Rv9_16 n9_16 n10_16 100
D9_17 n9_17 0 dm
Rh9_17 n9_17 n9_18 100
Rv9_17 n9_17 n10_17 100
D9_18 n9_18 0 dm
Rh9_18 n9_18 n9_19 100
Rv9_18 n9_18 n10_18 100
D9_19 n9_19 0 dm
Rh9_19 n9_19 n9_20 100
Rv9_19 n9_19 n10_19 100
D9_20 n9_20 0 dm
Rh9_20 n9_20 n9_21 100
Rv9_20 n9_20 n10_20 100
D9_21 n9_21 0 dm
Rh9_21 n9_21 n9_22 100
Rv9_21 n9_21 n10_21 100
D9_22 n9_22 0 dm
Rh9_22 n9_22 n9_23 100
Rv9_22 n9_22 n10_22 100
D9_23 n9_23 0 dm
Rh9_23 n9_23 n9_24 100
Rv9_23 n9_23 n10_23 100
D9_24 n9_24 0 dm
Rh9_24 n9_24 n9_25 100
Rv9_24 n9_24 n10_24 100
D9_25 n9_25 0 dm
Rh9_25 n9_25 n9_26 100
Rv9_25 n9_25 n10_25 100
D9_26 n9_26 0 dm
Rh9_26 n9_26 n9_27 100
Rv9_26 n9_26 n10_26 100
D9_27 n9_27 0 dm
Rh9_27 n9_27 n9_28 100
Rv9_27 n9_27 n10_27 100
D9_28 n9_28 0 dm
Rh9_28 n9_28 n9_29 100
Rv9_28 n9_28 n10_28 100
D9_29 n9_29 0 dm
Rh9_29 n9_29 n9_30 100
Rv9_29 n9_29 n10_29 100
D9_30 n9_30 0 dm
Rh9_30 n9_30 n9_31 100
Rv9_30 n9_30 n10_30 100
D9_31 n9_31 0 dm
Rv9_31 n9_31 n10_31 100
D10_0 n10_0 0 dm
Rh10_0 n10_0 n10_1 100
Rv10_0 n10_0 n11_0 100
D10_1 n10_1 0 dm
Rh10_1 n10_1 n10_2 100
Rv10_1 n10_1 n11_1 100
D10_2 n10_2 0 dm
Rh10_2 n10_2 n10_3 100
Rv10_2 n10_2 n11_2 100
D10_3 n10_3 0 dm
Rh10_3 n10_3 n10_4 100
Rv10_3 n10_3 n11_3 100
D10_4 n10_4 0 dm
Rh10_4 n10_4 n10_5 100
Rv10_4 n10_4 n11_4 100
D10_5 n10_5 0 dm
Rh10_5 n10_5 n10_6 100
Rv10_5 n10_5 n11_5 100
D10_6 n10_6 0 dm
Rh10_6 n10_6 n10_7 100
Rv10_6 n10_6 n11_6 100
D10_7 n10_7 0 dm
Rh10_7 n10_7 n10_8 100
Rv10_7 n10_7 n11_7 100
D10_8 n10_8 0 dm
Rh10_8 n10_8 n10_9 100
Rv10_8 n10_8 n11_8 100
D10_9 n10_9 0 dm
Rh10_9 n10_9 n10_10 100
Rv10_9 n10_9 n11_9 100
D10_10 n10_10 0 dm
Rh10_10 n10_10 n10_11 100
Rv10_10 n10_10 n11_10 100
D10_11 n10_11 0 dm
Rh10_11 n10_11 n10_12 100
Rv10_11 n10_11 n11_11 100
D10_12 n10_12 0 dm
Rh10_12 n10_12 n10_13 100
Rv10_12 n10_12 n11_12 100
D10_13 n10_13 0 dm
Rh10_13 n10_13 n10_14 100
Rv10_13 n10_13 n11_13 100
D10_14 n10_14 0 dm
Rh10_14 n10_14 n10_15 100
Rv10_14 n10_14 n11_14 100
D10_15 n10_15 0 dm
Rh10_15 n10_15 n10_16 100
Rv10_15 n10_15 n11_15 100
D10_16 n10_16 0 dm
Rh10_16 n10_16 n10_17 100
Rv10_16 n10_16 n11_16 100
D10_17 n10_17 0 dm
Rh10_17 n10_17 n10_18 100
Rv10_17 n10_17 n11_17 100
D10_18 n10_18 0 dm
Rh10_18 n10_18 n10_19 100
Rv10_18 n10_18 n11_18 100
D10_19 n10_19 0 dm
Rh10_19 n10_19 n10_20 100
Rv10_19 n10_19 n11_19 100
D10_20 n10_20 0 dm
Rh10_20 n10_20 n10_21 100
Rv10_20 n10_20 n11_20 100
D10_21 n10_21 0 dm
Rh10_21 n10_21 n10_22 100
Rv10_21 n10_21 n11_21 100
D10_22 n10_22 0 dm
Rh10_22 n10_22 n10_23 100
Rv10_22 n10_22 n11_22 100
D10_23 n10_23 0 dm
Rh10_23 n10_23 n10_24 100
Rv10_23 n10_23 n11_23 100
D10_24 n10_24 0 dm
Rh10_24 n10_24 n10_25 100
Rv10_24 n10_24 n11_24 100
D10_25 n10_25 0 dm
Rh10_25 n10_25 n10_26 100
Rv10_25 n10_25 n11_25 100
D10_26 n10_26 0 dm
Rh10_26 n10_26 n10_27 100
Rv10_26 n10_26 n11_26 100
D10_27 n10_27 0 dm
Rh10_27 n10_27 n10_28 100
Rv10_27 n10_27 n11_27 100
D10_28 n10_28 0 dm
Rh10_28 n10_28 n10_29 100
Rv10_28 n10_28 n11_28 100
D10_29 n10_29 0 dm
Rh10_29 n10_29 n10_30 100
Rv10_29 n10_29 n11_29 100
D10_30 n10_30 0 dm
Rh10_30 n10_30 n10_31 100
Rv10_30 n10_30 n11_30 100
D10_31 n10_31 0 dm
Rv10_31 n10_31 n11_31 100
D11_0 n11_0 0 dm
Rh11_0 n11_0 n11_1 100
Rv11_0 n11_0 n12_0 100
D11_1 n11_1 0 dm
Rh11_1 n11_1 n11_2 100
Rv11_1 n11_1 n12_1 100
D11_2 n11_2 0 dm
Rh11_2 n11_2 n11_3 100
Rv11_2 n11_2 n12_2 100
D11_3 n11_3 0 dm
Rh11_3 n11_3 n11_4 100
Rv11_3 n11_3 n12_3 100
D11_4 n11_4 0 dm
Rh11_4 n11_4 n11_5 100
Rv11_4 n11_4 n12_4 100
D11_5 n11_5 0 dm
Rh11_5 n11_5 n11_6 100
Rv11_5 n11_5 n12_5 100
D11_6 n11_6 0 dm
Rh11_6 n11_6 n11_7 100
Rv11_6 n11_6 n12_6 100
D11_7 n11_7 0 dm
Rh11_7 n11_7 n11_8 100
Rv11_7 n11_7 n12_7 100
D11_8 n11_8 0 dm
Rh11_8 n11_8 n11_9 100
Rv11_8 n11_8 n12_8 100
D11_9 n11_9 0 dm
Rh11_9 n11_9 n11_10 100
Rv11_9 n11_9 n12_9 100
D11_10 n11_10 0 dm
Rh11_10 n11_10 n11_11 100
Rv11_10 n11_10 n12_10 100
D11_11 n11_11 0 dm
Rh11_11 n11_11 n11_12 100
Rv11_11 n11_11 n12_11 100
D11_12 n11_12 0 dm
Rh11_12 n11_12 n11_13 100
Rv11_12 n11_12 n12_12 100
D11_13 n11_13 0 dm
Rh11_13 n11_13 n11_14 100
Rv11_13 n11_13 n12_13 100
D11_14 n11_14 0 dm
Rh11_14 n11_14 n11_15 100
Rv11_14 n11_14 n12_14 100
D11_15 n11_15 0 dm
Rh11_15 n11_15 n11_16 100
Rv11_15 n11_15 n12_15 100
D11_16 n11_16 0 dm
Rh11_16 n11_16 n11_17 100
Rv11_16 n11_16 n12_16 100
D11_17 n11_17 0 dm
Rh11_17 n11_17 n11_18 100
Rv11_17 n11_17 n12_17 100
D11_18 n11_18 0 dm
Rh11_18 n11_18 n11_19 100
Rv11_18 n11_18 n12_18 100
D11_19 n11_19 0 dm
Rh11_19 n11_19 n11_20 100
Rv11_19 n11_19 n12_19 100
D11_20 n11_20 0 dm
Rh11_20 n11_20 n11_21 100
Rv11_20 n11_20 n12_20 100
D11_21 n11_21 0 dm
Rh11_21 n11_21 n11_22 100
Rv11_21 n11_21 n12_21 100
D11_22 n11_22 0 dm
Rh11_22 n11_22 n11_23 100
Rv11_22 n11_22 n12_22 100
D11_23 n11_23 0 dm
Rh11_23 n11_23 n11_24 100
Rv11_23 n11_23 n12_23 100
D11_24 n11_24 0 dm
Rh11_24 n11_24 n11_25 100
Rv11_24 n11_24 n12_24 100
D11_25 n11_25 0 dm
Rh11_25 n11_25 n11_26 100
Rv11_25 n11_25 n12_25 100
D11_26 n11_26 0 dm
Rh11_26 n11_26 n11_27 100
Rv11_26 n11_26 n12_26 100
D11_27 n11_27 0 dm
Rh11_27 n11_27 n11_28 100
Rv11_27 n11_27 n12_27 100
D11_28 n11_28 0 dm
Rh11_28 n11_28 n11_29 100
Rv11_28 n11_28 n12_28 100
D11_29 n11_29 0 dm
Rh11_29 n11_29 n11_30 100
Rv11_29 n11_29 n12_29 100
D11_30 n11_30 0 dm
Rh11_30 n11_30 n11_31 100
Rv11_30 n11_30 n12_30 100
D11_31 n11_31 0 dm
Rv11_31 n11_31 n12_31 100
D12_0 n12_0 0 dm
Rh12_0 n12_0 n12_1 100
Rv12_0 n12_0 n13_0 100
D12_1 n12_1 0 dm
Rh12_1 n12_1 n12_2 100
Rv12_1 n12_1 n13_1 100
D12_2 n12_2 0 dm
Rh12_2 n12_2 n12_3 100
Rv12_2 n12_2 n13_2 100
D12_3 n12_3 0 dm
Rh12_3 n12_3 n12_4 100
Rv12_3 n12_3 n13_3 100
D12_4 n12_4 0 dm
Rh12_4 n12_4 n12_5 100
Rv12_4 n12_4 n13_4 100
D12_5 n12_5 0 dm
Rh12_5 n12_5 n12_6 100
Rv12_5 n12_5 n13_5 100
D12_6 n12_6 0 dm
Rh12_6 n12_6 n12_7 100
Rv12_6 n12_6 n13_6 100
D12_7 n12_7 0 dm
Rh12_7 n12_7 n12_8 100
Rv12_7 n12_7 n13_7 100
D12_8 n12_8 0 dm
Rh12_8 n12_8 n12_9 100
Rv12_8 n12_8 n13_8 100
D12_9 n12_9 0 dm
Rh12_9 n12_9 n12_10 100
Rv12_9 n12_9 n13_9 100
D12_10 n12_10 0 dm
Rh12_10 n12_10 n12_11 100
Rv12_10 n12_10 n13_10 100
D12_11 n12_11 0 dm
Rh12_11 n12_11 n12_12 100
Rv12_11 n12_11 n13_11 100
D12_12 n12_12 0 dm
Rh12_12 n12_12 n12_13 100
Rv12_12 n12_12 n13_12 100
D12_13 n12_13 0 dm
Rh12_13 n12_13 n12_14 100
Rv12_13 n12_13 n13_13 100
D12_14 n12_14 0 dm
Rh12_14 n12_14 n12_15 100
Rv12_14 n12_14 n13_14 100
D12_15 n12_15 0 dm
Rh12_15 n12_15 n12_16 100
Rv12_15 n12_15 n13_15 100
D12_16 n12_16 0 dm
Rh12_16 n12_16 n12_17 100
Rv12_16 n12_16 n13_16 100
D12_17 n12_17 0 dm
Rh12_17 n12_17 n12_18 100
Rv12_17 n12_17 n13_17 100
D12_18 n12_18 0 dm
Rh12_18 n12_18 n12_19 100
Rv12_18 n12_18 n13_18 100
D12_19 n12_19 0 dm
Rh12_19 n12_19 n12_20 100
Rv12_19 n12_19 n13_19 100
D12_20 n12_20 0 dm
Rh12_20 n12_20 n12_21 100
Rv12_20 n12_20 n13_20 100
D12_21 n12_21 0 dm
Rh12_21 n12_21 n12_22 100
Rv12_21 n12_21 n13_21 100
D12_22 n12_22 0 dm
Rh12_22 n12_22 n12_23 100
Rv12_22 n12_22 n13_22 100
D12_23 n12_23 0 dm
Rh12_23 n12_23 n12_24 100
Rv12_23 n12_23 n13_23 100
D12_24 n12_24 0 dm
Rh12_24 n12_24 n12_25 100
Rv12_24 n12_24 n13_24 100
D12_25 n12_25 0 dm
Rh12_25 n12_25 n12_26 100
Rv12_25 n12_25 n13_25 100
D12_26 n12_26 0 dm
Rh12_26 n12_26 n12_27 100
Rv12_26 n12_26 n13_26 100
D12_27 n12_27 0 dm
Rh12_27 n12_27 n12_28 100
Rv12_27 n12_27 n13_27 100
D12_28 n12_28 0 dm
Rh12_28 n12_28 n12_29 100
Rv12_28 n12_28 n13_28 100
D12_29 n12_29 0 dm
Rh12_29 n12_29 n12_30 100
Rv12_29 n12_29 n13_29 100
D12_30 n12_30 0 dm
Rh12_30 n12_30 n12_31 100
Rv12_30 n12_30 n13_30 100
D12_31 n12_31 0 dm
Rv12_31 n12_31 n13_31 100
D13_0 n13_0 0 dm
Rh13_0 n13_0 n13_1 100
Rv13_0 n13_0 n14_0 100
D13_1 n13_1 0 dm
Rh13_1 n13_1 n13_2 100
Rv13_1 n13_1 n14_1 100
D13_2 n13_2 0 dm
Rh13_2 n13_2 n13_3 100
Rv13_2 n13_2 n14_2 100
D13_3 n13_3 0 dm
Rh13_3 n13_3 n13_4 100
Rv13_3 n13_3 n14_3 100
D13_4 n13_4 0 dm
Rh13_4 n13_4 n13_5 100
Rv13_4 n13_4 n14_4 100
D13_5 n13_5 0 dm
Rh13_5 n13_5 n13_6 100
Rv13_5 n13_5 n14_5 100
D13_6 n13_6 0 dm
Rh13_6 n13_6 n13_7 100
Rv13_6 n13_6 n14_6 100
D13_7 n13_7 0 dm
Rh13_7 n13_7 n13_8 100
Rv13_7 n13_7 n14_7 100
D13_8 n13_8 0 dm
Rh13_8 n13_8 n13_9 100
Rv13_8 n13_8 n14_8 100
D13_9 n13_9 0 dm
Rh13_9 n13_9 n13_10 100
Rv13_9 n13_9 n14_9 100
D13_10 n13_10 0 dm
Rh13_10 n13_10 n13_11 100
Rv13_10 n13_10 n14_10 100
D13_11 n13_11 0 dm
Rh13_11 n13_11 n13_12 100
Rv13_11 n13_11 n14_11 100
D13_12 n13_12 0 dm
Rh13_12 n13_12 n13_13 100
Rv13_12 n13_12 n14_12 100
D13_13 n13_13 0 dm
Rh13_13 n13_13 n13_14 100
Rv13_13 n13_13 n14_13 100
D13_14 n13_14 0 dm
Rh13_14 n13_14 n13_15 100
Rv13_14 n13_14 n14_14 100
D13_15 n13_15 0 dm
Rh13_15 n13_15 n13_16 100
Rv13_15 n13_15 n14_15 100
D13_16 n13_16 0 dm
Rh13_16 n13_16 n13_17 100
Rv13_16 n13_16 n14_16 100
D13_17 n13_17 0 dm
Rh13_17 n13_17 n13_18 100
Rv13_17 n13_17 n14_17 100
D13_18 n13_18 0 dm
Rh13_18 n13_18 n13_19 100
Rv13_18 n13_18 n14_18 100
D13_19 n13_19 0 dm
Rh13_19 n13_19 n13_20 100
Rv13_19 n13_19 n14_19 100
D13_20 n13_20 0 dm
Rh13_20 n13_20 n13_21 100
Rv13_20 n13_20 n14_20 100
D13_21 n13_21 0 dm
Rh13_21 n13_21 n13_22 100
Rv13_21 n13_21 n14_21 100
D13_22 n13_22 0 dm
Rh13_22 n13_22 n13_23 100
Rv13_22 n13_22 n14_22 100
D13_23 n13_23 0 dm
Rh13_23 n13_23 n13_24 100
Rv13_23 n13_23 n14_23 100
D13_24 n13_24 0 dm
Rh13_24 n13_24 n13_25 100
Rv13_24 n13_24 n14_24 100
D13_25 n13_25 0 dm
Rh13_25 n13_25 n13_26 100
Rv13_25 n13_25 n14_25 100
D13_26 n13_26 0 dm
Rh13_26 n13_26 n13_27 100
Rv13_26 n13_26 n14_26 100
D13_27 n13_27 0 dm
Rh13_27 n13_27 n13_28 100
Rv13_27 n13_27 n14_27 100
D13_28 n13_28 0 dm
Rh13_28 n13_28 n13_29 100
Rv13_28 n13_28 n14_28 100
D13_29 n13_29 0 dm
Rh13_29 n13_29 n13_30 100
Rv13_29 n13_29 n14_29 100
D13_30 n13_30 0 dm
Rh13_30 n13_30 n13_31 100
Rv13_30 n13_30 n14_30 100
D13_31 n13_31 0 dm
Rv13_31 n13_31 n14_31 100
D14_0 n14_0 0 dm
Rh14_0 n14_0 n14_1 100
Rv14_0 n14_0 n15_0 100
D14_1 n14_1 0 dm
Rh14_1 n14_1 n14_2 100
Rv14_1 n14_1 n15_1 100
D14_2 n14_2 0 dm
Rh14_2 n14_2 n14_3 100
Rv14_2 n14_2 n15_2 100
D14_3 n14_3 0 dm
Rh14_3 n14_3 n14_4 100
Rv14_3 n14_3 n15_3 100
D14_4 n14_4 0 dm
Rh14_4 n14_4 n14_5 100
Rv14_4 n14_4 n15_4 100
D14_5 n14_5 0 dm
Rh14_5 n14_5 n14_6 100
Rv14_5 n14_5 n15_5 100
D14_6 n14_6 0 dm
Rh14_6 n14_6 n14_7 100
Rv14_6 n14_6 n15_6 100
D14_7 n14_7 0 dm
Rh14_7 n14_7 n14_8 100
Rv14_7 n14_7 n15_7 100
D14_8 n14_8 0 dm
Rh14_8 n14_8 n14_9 100
Rv14_8 n14_8 n15_8 100
D14_9 n14_9 0 dm
Rh14_9 n14_9 n14_10 100
Rv14_9 n14_9 n15_9 100
D14_10 n14_10 0 dm
Rh14_10 n14_10 n14_11 100
Rv14_10 n14_10 n15_10 100
D14_11 n14_11 0 dm
Rh14_11 n14_11 n14_12 100
Rv14_11 n14_11 n15_11 100
D14_12 n14_12 0 dm
Rh14_12 n14_12 n14_13 100
Rv14_12 n14_12 n15_12 100
D14_13 n14_13 0 dm
Rh14_13 n14_13 n14_14 100
Rv14_13 n14_13 n15_13 100
D14_14 n14_14 0 dm
Rh14_14 n14_14 n14_15 100
Rv14_14 n14_14 n15_14 100
D14_15 n14_15 0 dm
Rh14_15 n14_15 n14_16 100
Rv14_15 n14_15 n15_15 100
D14_16 n14_16 0 dm
Rh14_16 n14_16 n14_17 100
Rv14_16 n14_16 n15_16 100
D14_17 n14_17 0 dm
Rh14_17 n14_17 n14_18 100
Rv14_17 n14_17 n15_17 100
D14_18 n14_18 0 dm
Rh14_18 n14_18 n14_19 100
Rv14_18 n14_18 n15_18 100
D14_19 n14_19 0 dm
Rh14_19 n14_19 n14_20 100
Rv14_19 n14_19 n15_19 100
D14_20 n14_20 0 dm
Rh14_20 n14_20 n14_21 100
Rv14_20 n14_20 n15_20 100
D14_21 n14_21 0 dm
Rh14_21 n14_21 n14_22 100
Rv14_21 n14_21 n15_21 100
D14_22 n14_22 0 dm
Rh14_22 n14_22 n14_23 100
Rv14_22 n14_22 n15_22 100
D14_23 n14_23 0 dm
Rh14_23 n14_23 n14_24 100
Rv14_23 n14_23 n15_23 100
D14_24 n14_24 0 dm
Rh14_24 n14_24 n14_25 100
Rv14_24 n14_24 n15_24 100
D14_25 n14_25 0 dm
Rh14_25 n14_25 n14_26 100
Rv14_25 n14_25 n15_25 100
D14_26 n14_26 0 dm
Rh14_26 n14_26 n14_27 100
Rv14_26 n14_26 n15_26 100
D14_27 n14_27 0 dm
Rh14_27 n14_27 n14_28 100
Rv14_27 n14_27 n15_27 100
D14_28 n14_28 0 dm
Rh14_28 n14_28 n14_29 100
Rv14_28 n14_28 n15_28 100
D14_29 n14_29 0 dm
Rh14_29 n14_29 n14_30 100
Rv14_29 n14_29 n15_29 100
D14_30 n14_30 0 dm
Rh14_30 n14_30 n14_31 100
Rv14_30 n14_30 n15_30 100
D14_31 n14_31 0 dm
Rv14_31 n14_31 n15_31 100
D15_0 n15_0 0 dm
Rh15_0 n15_0 n15_1 100
Rv15_0 n15_0 n16_0 100
D15_1 n15_1 0 dm
Rh15_1 n15_1 n15_2 100
Rv15_1 n15_1 n16_1 100
D15_2 n15_2 0 dm
Rh15_2 n15_2 n15_3 100
Rv15_2 n15_2 n16_2 100
D15_3 n15_3 0 dm
Rh15_3 n15_3 n15_4 100
Rv15_3 n15_3 n16_3 100
D15_4 n15_4 0 dm
Rh15_4 n15_4 n15_5 100
Rv15_4 n15_4 n16_4 100
D15_5 n15_5 0 dm
Rh15_5 n15_5 n15_6 100
Rv15_5 n15_5 n16_5 100
D15_6 n15_6 0 dm
Rh15_6 n15_6 n15_7 100
Rv15_6 n15_6 n16_6 100
D15_7 n15_7 0 dm
Rh15_7 n15_7 n15_8 100
Rv15_7 n15_7 n16_7 100
D15_8 n15_8 0 dm
Rh15_8 n15_8 n15_9 100
Rv15_8 n15_8 n16_8 100
D15_9 n15_9 0 dm
Rh15_9 n15_9 n15_10 100
Rv15_9 n15_9 n16_9 100
D15_10 n15_10 0 dm
Rh15_10 n15_10 n15_11 100
Rv15_10 n15_10 n16_10 100
D15_11 n15_11 0 dm
Rh15_11 n15_11 n15_12 100
Rv15_11 n15_11 n16_11 100
D15_12 n15_12 0 dm
Rh15_12 n15_12 n15_13 100
Rv15_12 n15_12 n16_12 100
D15_13 n15_13 0 dm
Rh15_13 n15_13 n15_14 100
Rv15_13 n15_13 n16_13 100
D15_14 n15_14 0 dm
Rh15_14 n15_14 n15_15 100
Rv15_14 n15_14 n16_14 100
D15_15 n15_15 0 dm
Rh15_15 n15_15 n15_16 100
Rv15_15 n15_15 n16_15 100
D15_16 n15_16 0 dm
Rh15_16 n15_16 n15_17 100
Rv15_16 n15_16 n16_16 100
D15_17 n15_17 0 dm
Rh15_17 n15_17 n15_18 100
Rv15_17 n15_17 n16_17 100
D15_18 n15_18 0 dm
Rh15_18 n15_18 n15_19 100
Rv15_18 n15_18 n16_18 100
D15_19 n15_19 0 dm
Rh15_19 n15_19 n15_20 100
Rv15_19 n15_19 n16_19 100
D15_20 n15_20 0 dm
Rh15_20 n15_20 n15_21 100
Rv15_20 n15_20 n16_20 100
D15_21 n15_21 0 dm
Rh15_21 n15_21 n15_22 100
Rv15_21 n15_21 n16_21 100
D15_22 n15_22 0 dm
Rh15_22 n15_22 n15_23 100
Rv15_22 n15_22 n16_22 100
D15_23 n15_23 0 dm
Rh15_23 n15_23 n15_24 100
Rv15_23 n15_23 n16_23 100
D15_24 n15_24 0 dm
Rh15_24 n15_24 n15_25 100
Rv15_24 n15_24 n16_24 100
D15_25 n15_25 0 dm
Rh15_25 n15_25 n15_26 100
Rv15_25 n15_25 n16_25 100
D15_26 n15_26 0 dm
Rh15_26 n15_26 n15_27 100
Rv15_26 n15_26 n16_26 100
D15_27 n15_27 0 dm
Rh15_27 n15_27 n15_28 100
Rv15_27 n15_27 n16_27 100
D15_28 n15_28 0 dm
Rh15_28 n15_28 n15_29 100
Rv15_28 n15_28 n16_28 100
D15_29 n15_29 0 dm
Rh15_29 n15_29 n15_30 100
Rv15_29 n15_29 n16_29 100
D15_30 n15_30 0 dm
Rh15_30 n15_30 n15_31 100
Rv15_30 n15_30 n16_30 100
D15_31 n15_31 0 dm
Rv15_31 n15_31 n16_31 100
D16_0 n16_0 0 dm
Rh16_0 n16_0 n16_1 100
Rv16_0 n16_0 n17_0 100
D16_1 n16_1 0 dm
Rh16_1 n16_1 n16_2 100
Rv16_1 n16_1 n17_1 100
D16_2 n16_2 0 dm
Rh16_2 n16_2 n16_3 100
Rv16_2 n16_2 n17_2 100
D16_3 n16_3 0 dm
Rh16_3 n16_3 n16_4 100
Rv16_3 n16_3 n17_3 100
D16_4 n16_4 0 dm
Rh16_4 n16_4 n16_5 100
Rv16_4 n16_4 n17_4 100
D16_5 n16_5 0 dm
Rh16_5 n16_5 n16_6 100
Rv16_5 n16_5 n17_5 100
D16_6 n16_6 0 dm
Rh16_6 n16_6 n16_7 100
Rv16_6 n16_6 n17_6 100
D16_7 n16_7 0 dm
Rh16_7 n16_7 n16_8 100
Rv16_7 n16_7 n17_7 100
D16_8 n16_8 0 dm
Rh16_8 n16_8 n16_9 100
Rv16_8 n16_8 n17_8 100
D16_9 n16_9 0 dm
Rh16_9 n16_9 n16_10 100
Rv16_9 n16_9 n17_9 100
D16_10 n16_10 0 dm
Rh16_10 n16_10 n16_11 100
Rv16_10 n16_10 n17_10 100
D16_11 n16_11 0 dm
Rh16_11 n16_11 n16_12 100
Rv16_11 n16_11 n17_11 100
D16_12 n16_12 0 dm
Rh16_12 n16_12 n16_13 100
Rv16_12 n16_12 n17_12 100
D16_13 n16_13 0 dm
Rh16_13 n16_13 n16_14 100
Rv16_13 n16_13 n17_13 100
D16_14 n16_14 0 dm
Rh16_14 n16_14 n16_15 100
Rv16_14 n16_14 n17_14 100
D16_15 n16_15 0 dm
Rh16_15 n16_15 n16_16 100
Rv16_15 n16_15 n17_15 100
D16_16 n16_16 0 dm
Rh16_16 n16_16 n16_17 100
Rv16_16 n16_16 n17_16 100
D16_17 n16_17 0 dm
Rh16_17 n16_17 n16_18 100
Rv16_17 n16_17 n17_17 100
D16_18 n16_18 0 dm
Rh16_18 n16_18 n16_19 100
Rv16_18 n16_18 n17_18 100
D16_19 n16_19 0 dm
Rh16_19 n16_19 n16_20 100
Rv16_19 n16_19 n17_19 100
D16_20 n16_20 0 dm
Rh16_20 n16_20 n16_21 100
Rv16_20 n16_20 n17_20 100
D16_21 n16_21 0 dm
Rh16_21 n16_21 n16_22 100
Rv16_21 n16_21 n17_21 100
D16_22 n16_22 0 dm
Rh16_22 n16_22 n16_23 100
Rv16_22 n16_22 n17_22 100
D16_23 n16_23 0 dm
Rh16_23 n16_23 n16_24 100
Rv16_23 n16_23 n17_23 100
D16_24 n16_24 0 dm
Rh16_24 n16_24 n16_25 100
Rv16_24 n16_24 n17_24 100
D16_25 n16_25 0 dm
Rh16_25 n16_25 n16_26 100
Rv16_25 n16_25 n17_25 100
D16_26 n16_26 0 dm
Rh16_26 n16_26 n16_27 100
Rv16_26 n16_26 n17_26 100
D16_27 n16_27 0 dm
Rh16_27 n16_27 n16_28 100
Rv16_27 n16_27 n17_27 100
D16_28 n16_28 0 dm
Rh16_28 n16_28 n16_29 100
Rv16_28 n16_28 n17_28 100
D16_29 n16_29 0 dm
Rh16_29 n16_29 n16_30 100
Rv16_29 n16_29 n17_29 100
D16_30 n16_30 0 dm
Rh16_30 n16_30 n16_31 100
Rv16_30 n16_30 n17_30 100
D16_31 n16_31 0 dm
Rv16_31 n16_31 n17_31 100
D17_0 n17_0 0 dm
Rh17_0 n17_0 n17_1 100
Rv17_0 n17_0 n18_0 100
D17_1 n17_1 0 dm
Rh17_1 n17_1 n17_2 100
Rv17_1 n17_1 n18_1 100
D17_2 n17_2 0 dm
Rh17_2 n17_2 n17_3 100
Rv17_2 n17_2 n18_2 100
D17_3 n17_3 0 dm
Rh17_3 n17_3 n17_4 100
Rv17_3 n17_3 n18_3 100
D17_4 n17_4 0 dm
Rh17_4 n17_4 n17_5 100
Rv17_4 n17_4 n18_4 100
D17_5 n17_5 0 dm
Rh17_5 n17_5 n17_6 100
Rv17_5 n17_5 n18_5 100
D17_6 n17_6 0 dm
Rh17_6 n17_6 n17_7 100
Rv17_6 n17_6 n18_6 100
D17_7 n17_7 0 dm
Rh17_7 n17_7 n17_8 100
Rv17_7 n17_7 n18_7 100
D17_8 n17_8 0 dm
Rh17_8 n17_8 n17_9 100
Rv17_8 n17_8 n18_8 100
D17_9 n17_9 0 dm
Rh17_9 n17_9 n17_10 100
Rv17_9 n17_9 n18_9 100
D17_10 n17_10 0 dm
Rh17_10 n17_10 n17_11 100
Rv17_10 n17_10 n18_10 100
D17_11 n17_11 0 dm
Rh17_11 n17_11 n17_12 100
Rv17_11 n17_11 n18_11 100
D17_12 n17_12 0 dm
Rh17_12 n17_12 n17_13 100
Rv17_12 n17_12 n18_12 100
D17_13 n17_13 0 dm
Rh17_13 n17_13 n17_14 100
Rv17_13 n17_13 n18_13 100
D17_14 n17_14 0 dm
Rh17_14 n17_14 n17_15 100
Rv17_14 n17_14 n18_14 100
D17_15 n17_15 0 dm
Rh17_15 n17_15 n17_16 100
Rv17_15 n17_15 n18_15 100
D17_16 n17_16 0 dm
Rh17_16 n17_16 n17_17 100
Rv17_16 n17_16 n18_16 100
D17_17 n17_17 0 dm
Rh17_17 n17_17 n17_18 100
Rv17_17 n17_17 n18_17 100
D17_18 n17_18 0 dm
Rh17_18 n17_18 n17_19 100
Rv17_18 n17_18 n18_18 100
D17_19 n17_19 0 dm
Rh17_19 n17_19 n17_20 100
Rv17_19 n17_19 n18_19 100
D17_20 n17_20 0 dm
Rh17_20 n17_20 n17_21 100
Rv17_20 n17_20 n18_20 100
D17_21 n17_21 0 dm
Rh17_21 n17_21 n17_22 100
Rv17_21 n17_21 n18_21 100
D17_22 n17_22 0 dm
Rh17_22 n17_22 n17_23 100
Rv17_22 n17_22 n18_22 100
D17_23 n17_23 0 dm
Rh17_23 n17_23 n17_24 100
Rv17_23 n17_23 n18_23 100
D17_24 n17_24 0 dm
Rh17_24 n17_24 n17_25 100
Rv17_24 n17_24 n18_24 100
D17_25 n17_25 0 dm
Rh17_25 n17_25 n17_26 100
Rv17_25 n17_25 n18_25 100
D17_26 n17_26 0 dm
Rh17_26 n17_26 n17_27 100
Rv17_26 n17_26 n18_26 100
D17_27 n17_27 0 dm
Rh17_27 n17_27 n17_28 100
Rv17_27 n17_27 n18_27 100
D17_28 n17_28 0 dm
Rh17_28 n17_28 n17_29 100
Rv17_28 n17_28 n18_28 100
D17_29 n17_29 0 dm
Rh17_29 n17_29 n17_30 100
Rv17_29 n17_29 n18_29 100
D17_30 n17_30 0 dm
Rh17_30 n17_30 n17_31 100
Rv17_30 n17_30 n18_30 100
D17_31 n17_31 0 dm
Rv17_31 n17_31 n18_31 100
D18_0 n18_0 0 dm
Rh18_0 n18_0 n18_1 100
Rv18_0 n18_0 n19_0 100
D18_1 n18_1 0 dm
Rh18_1 n18_1 n18_2 100
Rv18_1 n18_1 n19_1 100
D18_2 n18_2 0 dm
Rh18_2 n18_2 n18_3 100
Rv18_2 n18_2 n19_2 100
D18_3 n18_3 0 dm
Rh18_3 n18_3 n18_4 100
Rv18_3 n18_3 n19_3 100
D18_4 n18_4 0 dm
Rh18_4 n18_4 n18_5 100
Rv18_4 n18_4 n19_4 100
D18_5 n18_5 0 dm
Rh18_5 n18_5 n18_6 100
Rv18_5 n18_5 n19_5 100
D18_6 n18_6 0 dm
Rh18_6 n18_6 n18_7 100
Rv18_6 n18_6 n19_6 100
D18_7 n18_7 0 dm
Rh18_7 n18_7 n18_8 100
Rv18_7 n18_7 n19_7 100
D18_8 n18_8 0 dm
Rh18_8 n18_8 n18_9 100
Rv18_8 n18_8 n19_8 100
D18_9 n18_9 0 dm
Rh18_9 n18_9 n18_10 100
Rv18_9 n18_9 n19_9 100
D18_10 n18_10 0 dm
Rh18_10 n18_10 n18_11 100
Rv18_10 n18_10 n19_10 100
D18_11 n18_11 0 dm
Rh18_11 n18_11 n18_12 100
Rv18_11 n18_11 n19_11 100
D18_12 n18_12 0 dm
Rh18_12 n18_12 n18_13 100
Rv18_12 n18_12 n19_12 100
D18_13 n18_13 0 dm
Rh18_13 n18_13 n18_14 100
Rv18_13 n18_13 n19_13 100
D18_14 n18_14 0 dm
Rh18_14 n18_14 n18_15 100
Rv18_14 n18_14 n19_14 100
D18_15 n18_15 0 dm
Rh18_15 n18_15 n18_16 100
Rv18_15 n18_15 n19_15 100
D18_16 n18_16 0 dm
Rh18_16 n18_16 n18_17 100
Rv18_16 n18_16 n19_16 100
D18_17 n18_17 0 dm
Rh18_17 n18_17 n18_18 100
Rv18_17 n18_17 n19_17 100
D18_18 n18_18 0 dm
Rh18_18 n18_18 n18_19 100
Rv18_18 n18_18 n19_18 100
D18_19 n18_19 0 dm
Rh18_19 n18_19 n18_20 100
Rv18_19 n18_19 n19_19 100
D18_20 n18_20 0 dm
Rh18_20 n18_20 n18_21 100
Rv18_20 n18_20 n19_20 100
D18_21 n18_21 0 dm
Rh18_21 n18_21 n18_22 100
Rv18_21 n18_21 n19_21 100
D18_22 n18_22 0 dm
Rh18_22 n18_22 n18_23 100
Rv18_22 n18_22 n19_22 100
D18_23 n18_23 0 dm
Rh18_23 n18_23 n18_24 100
Rv18_23 n18_23 n19_23 100
D18_24 n18_24 0 dm
Rh18_24 n18_24 n18_25 100
Rv18_24 n18_24 n19_24 100
D18_25 n18_25 0 dm
Rh18_25 n18_25 n18_26 100
Rv18_25 n18_25 n19_25 100
D18_26 n18_26 0 dm
Rh18_26 n18_26 n18_27 100
Rv18_26 n18_26 n19_26 100
D18_27 n18_27 0 dm
Rh18_27 n18_27 n18_28 100
Rv18_27 n18_27 n19_27 100
D18_28 n18_28 0 dm
Rh18_28 n18_28 n18_29 100
Rv18_28 n18_28 n19_28 100
D18_29 n18_29 0 dm
Rh18_29 n18_29 n18_30 100
Rv18_29 n18_29 n19_29 100
D18_30 n18_30 0 dm
Rh18_30 n18_30 n18_31 100
Rv18_30 n18_30 n19_30 100
D18_31 n18_31 0 dm
Rv18_31 n18_31 n19_31 100
D19_0 n19_0 0 dm
Rh19_0 n19_0 n19_1 100
Rv19_0 n19_0 n20_0 100
D19_1 n19_1 0 dm
Rh19_1 n19_1 n19_2 100
Rv19_1 n19_1 n20_1 100
D19_2 n19_2 0 dm
Rh19_2 n19_2 n19_3 100
Rv19_2 n19_2 n20_2 100
D19_3 n19_3 0 dm
Rh19_3 n19_3 n19_4 100
Rv19_3 n19_3 n20_3 100
D19_4 n19_4 0 dm
Rh19_4 n19_4 n19_5 100
Rv19_4 n19_4 n20_4 100
D19_5 n19_5 0 dm
Rh19_5 n19_5 n19_6 100
Rv19_5 n19_5 n20_5 100
D19_6 n19_6 0 dm
Rh19_6 n19_6 n19_7 100
Rv19_6 n19_6 n20_6 100
D19_7 n19_7 0 dm
Rh19_7 n19_7 n19_8 100
Rv19_7 n19_7 n20_7 100
D19_8 n19_8 0 dm
Rh19_8 n19_8 n19_9 100
Rv19_8 n19_8 n20_8 100
D19_9 n19_9 0 dm
Rh19_9 n19_9 n19_10 100
Rv19_9 n19_9 n20_9 100
D19_10 n19_10 0 dm
Rh19_10 n19_10 n19_11 100
Rv19_10 n19_10 n20_10 100
D19_11 n19_11 0 dm
Rh19_11 n19_11 n19_12 100
Rv19_11 n19_11 n20_11 100
D19_12 n19_12 0 dm
Rh19_12 n19_12 n19_13 100
Rv19_12 n19_12 n20_12 100
D19_13 n19_13 0 dm
Rh19_13 n19_13 n19_14 100
Rv19_13 n19_13 n20_13 100
D19_14 n19_14 0 dm
Rh19_14 n19_14 n19_15 100
Rv19_14 n19_14 n20_14 100
D19_15 n19_15 0 dm
Rh19_15 n19_15 n19_16 100
Rv19_15 n19_15 n20_15 100
D19_16 n19_16 0 dm
Rh19_16 n19_16 n19_17 100
Rv19_16 n19_16 n20_16 100
D19_17 n19_17 0 dm
Rh19_17 n19_17 n19_18 100
Rv19_17 n19_17 n20_17 100
D19_18 n19_18 0 dm
Rh19_18 n19_18 n19_19 100
Rv19_18 n19_18 n20_18 100
D19_19 n19_19 0 dm
Rh19_19 n19_19 n19_20 100
Rv19_19 n19_19 n20_19 100
D19_20 n19_20 0 dm
Rh19_20 n19_20 n19_21 100
Rv19_20 n19_20 n20_20 100
D19_21 n19_21 0 dm
Rh19_21 n19_21 n19_22 100
Rv19_21 n19_21 n20_21 100
D19_22 n19_22 0 dm
Rh19_22 n19_22 n19_23 100
Rv19_22 n19_22 n20_22 100
D19_23 n19_23 0 dm
Rh19_23 n19_23 n19_24 100
Rv19_23 n19_23 n20_23 100
D19_24 n19_24 0 dm
Rh19_24 n19_24 n19_25 100
Rv19_24 n19_24 n20_24 100
D19_25 n19_25 0 dm
Rh19_25 n19_25 n19_26 100
Rv19_25 n19_25 n20_25 100
D19_26 n19_26 0 dm
Rh19_26 n19_26 n19_27 100
Rv19_26 n19_26 n20_26 100
D19_27 n19_27 0 dm
Rh19_27 n19_27 n19_28 100
Rv19_27 n19_27 n20_27 100
D19_28 n19_28 0 dm
Rh19_28 n19_28 n19_29 100
Rv19_28 n19_28 n20_28 100
D19_29 n19_29 0 dm
Rh19_29 n19_29 n19_30 100
Rv19_29 n19_29 n20_29 100
D19_30 n19_30 0 dm
Rh19_30 n19_30 n19_31 100
Rv19_30 n19_30 n20_30 100
D19_31 n19_31 0 dm
Rv19_31 n19_31 n20_31 100
D20_0 n20_0 0 dm
Rh20_0 n20_0 n20_1 100
Rv20_0 n20_0 n21_0 100
D20_1 n20_1 0 dm
Rh20_1 n20_1 n20_2 100
Rv20_1 n20_1 n21_1 100
D20_2 n20_2 0 dm
Rh20_2 n20_2 n20_3 100
Rv20_2 n20_2 n21_2 100
D20_3 n20_3 0 dm
Rh20_3 n20_3 n20_4 100
Rv20_3 n20_3 n21_3 100
D20_4 n20_4 0 dm
Rh20_4 n20_4 n20_5 100
Rv20_4 n20_4 n21_4 100
D20_5 n20_5 0 dm
Rh20_5 n20_5 n20_6 100
Rv20_5 n20_5 n21_5 100
D20_6 n20_6 0 dm
Rh20_6 n20_6 n20_7 100
Rv20_6 n20_6 n21_6 100
D20_7 n20_7 0 dm
Rh20_7 n20_7 n20_8 100
Rv20_7 n20_7 n21_7 100
D20_8 n20_8 0 dm
Rh20_8 n20_8 n20_9 100
Rv20_8 n20_8 n21_8 100
D20_9 n20_9 0 dm
Rh20_9 n20_9 n20_10 100
Rv20_9 n20_9 n21_9 100
D20_10 n20_10 0 dm
Rh20_10 n20_10 n20_11 100
Rv20_10 n20_10 n21_10 100
D20_11 n20_11 0 dm
Rh20_11 n20_11 n20_12 100
Rv20_11 n20_11 n21_11 100
D20_12 n20_12 0 dm
Rh20_12 n20_12 n20_13 100
Rv20_12 n20_12 n21_12 100
D20_13 n20_13 0 dm
Rh20_13 n20_13 n20_14 100
Rv20_13 n20_13 n21_13 100
D20_14 n20_14 0 dm
Rh20_14 n20_14 n20_15 100
Rv20_14 n20_14 n21_14 100
D20_15 n20_15 0 dm
Rh20_15 n20_15 n20_16 100
Rv20_15 n20_15 n21_15 100
D20_16 n20_16 0 dm
Rh20_16 n20_16 n20_17 100
Rv20_16 n20_16 n21_16 100
D20_17 n20_17 0 dm
Rh20_17 n20_17 n20_18 100
Rv20_17 n20_17 n21_17 100
D20_18 n20_18 0 dm
Rh20_18 n20_18 n20_19 100
Rv20_18 n20_18 n21_18 100
D20_19 n20_19 0 dm
Rh20_19 n20_19 n20_20 100
Rv20_19 n20_19 n21_19 100
D20_20 n20_20 0 dm
Rh20_20 n20_20 n20_21 100
Rv20_20 n20_20 n21_20 100
D20_21 n20_21 0 dm
Rh20_21 n20_21 n20_22 100
Rv20_21 n20_21 n21_21 100
D20_22 n20_22 0 dm
Rh20_22 n20_22 n20_23 100
Rv20_22 n20_22 n21_22 100
D20_23 n20_23 0 dm
Rh20_23 n20_23 n20_24 100
Rv20_23 n20_23 n21_23 100
D20_24 n20_24 0 dm
Rh20_24 n20_24 n20_25 100
Rv20_24 n20_24 n21_24 100
D20_25 n20_25 0 dm
Rh20_25 n20_25 n20_26 100
Rv20_25 n20_25 n21_25 100
D20_26 n20_26 0 dm
Rh20_26 n20_26 n20_27 100
Rv20_26 n20_26 n21_26 100
D20_27 n20_27 0 dm
Rh20_27 n20_27 n20_28 100
Rv20_27 n20_27 n21_27 100
D20_28 n20_28 0 dm
Rh20_28 n20_28 n20_29 100
Rv20_28 n20_28 n21_28 100
D20_29 n20_29 0 dm
Rh20_29 n20_29 n20_30 100
Rv20_29 n20_29 n21_29 100
D20_30 n20_30 0 dm
Rh20_30 n20_30 n20_31 100
Rv20_30 n20_30 n21_30 100
D20_31 n20_31 0 dm
Rv20_31 n20_31 n21_31 100
D21_0 n21_0 0 dm
Rh21_0 n21_0 n21_1 100
Rv21_0 n21_0 n22_0 100
D21_1 n21_1 0 dm
Rh21_1 n21_1 n21_2 100
Rv21_1 n21_1 n22_1 100
D21_2 n21_2 0 dm
Rh21_2 n21_2 n21_3 100
Rv21_2 n21_2 n22_2 100
D21_3 n21_3 0 dm
Rh21_3 n21_3 n21_4 100
Rv21_3 n21_3 n22_3 100
D21_4 n21_4 0 dm
Rh21_4 n21_4 n21_5 100
Rv21_4 n21_4 n22_4 100
D21_5 n21_5 0 dm
Rh21_5 n21_5 n21_6 100
Rv21_5 n21_5 n22_5 100
D21_6 n21_6 0 dm
Rh21_6 n21_6 n21_7 100
Rv21_6 n21_6 n22_6 100
D21_7 n21_7 0 dm
Rh21_7 n21_7 n21_8 100
Rv21_7 n21_7 n22_7 100
D21_8 n21_8 0 dm
Rh21_8 n21_8 n21_9 100
Rv21_8 n21_8 n22_8 100
D21_9 n21_9 0 dm
Rh21_9 n21_9 n21_10 100
Rv21_9 n21_9 n22_9 100
D21_10 n21_10 0 dm
Rh21_10 n21_10 n21_11 100
Rv21_10 n21_10 n22_10 100
D21_11 n21_11 0 dm
Rh21_11 n21_11 n21_12 100
Rv21_11 n21_11 n22_11 100
D21_12 n21_12 0 dm
Rh21_12 n21_12 n21_13 100
Rv21_12 n21_12 n22_12 100
D21_13 n21_13 0 dm
Rh21_13 n21_13 n21_14 100
Rv21_13 n21_13 n22_13 100
D21_14 n21_14 0 dm
Rh21_14 n21_14 n21_15 100
Rv21_14 n21_14 n22_14 100
D21_15 n21_15 0 dm
Rh21_15 n21_15 n21_16 100
Rv21_15 n21_15 n22_15 100
D21_16 n21_16 0 dm
Rh21_16 n21_16 n21_17 100
Rv21_16 n21_16 n22_16 100
D21_17 n21_17 0 dm
Rh21_17 n21_17 n21_18 100
Rv21_17 n21_17 n22_17 100
D21_18 n21_18 0 dm
Rh21_18 n21_18 n21_19 100
Rv21_18 n21_18 n22_18 100
D21_19 n21_19 0 dm
Rh21_19 n21_19 n21_20 100
Rv21_19 n21_19 n22_19 100
D21_20 n21_20 0 dm
Rh21_20 n21_20 n21_21 100
Rv21_20 n21_20 n22_20 100
D21_21 n21_21 0 dm
Rh21_21 n21_21 n21_22 100
Rv21_21 n21_21 n22_21 100
D21_22 n21_22 0 dm
Rh21_22 n21_22 n21_23 100
Rv21_22 n21_22 n22_22 100
D21_23 n21_23 0 dm
Rh21_23 n21_23 n21_24 100
Rv21_23 n21_23 n22_23 100
D21_24 n21_24 0 dm
Rh21_24 n21_24 n21_25 100
Rv21_24 n21_24 n22_24 100
D21_25 n21_25 0 dm
Rh21_25 n21_25 n21_26 100
Rv21_25 n21_25 n22_25 100
D21_26 n21_26 0 dm
Rh21_26 n21_26 n21_27 100
Rv21_26 n21_26 n22_26 100
D21_27 n21_27 0 dm
Rh21_27 n21_27 n21_28 100
Rv21_27 n21_27 n22_27 100
D21_28 n21_28 0 dm
Rh21_28 n21_28 n21_29 100
Rv21_28 n21_28 n22_28 100
D21_29 n21_29 0 dm
Rh21_29 n21_29 n21_30 100
Rv21_29 n21_29 n22_29 100
D21_30 n21_30 0 dm
Rh21_30 n21_30 n21_31 100
Rv21_30 n21_30 n22_30 100
D21_31 n21_31 0 dm
Rv21_31 n21_31 n22_31 100
D22_0 n22_0 0 dm
Rh22_0 n22_0 n22_1 100
Rv22_0 n22_0 n23_0 100
D22_1 n22_1 0 dm
Rh22_1 n22_1 n22_2 100
Rv22_1 n22_1 n23_1 100
D22_2 n22_2 0 dm
Rh22_2 n22_2 n22_3 100
Rv22_2 n22_2 n23_2 100
D22_3 n22_3 0 dm
Rh22_3 n22_3 n22_4 100
Rv22_3 n22_3 n23_3 100
D22_4 n22_4 0 dm
Rh22_4 n22_4 n22_5 100
Rv22_4 n22_4 n23_4 100
D22_5 n22_5 0 dm
Rh22_5 n22_5 n22_6 100
Rv22_5 n22_5 n23_5 100
D22_6 n22_6 0 dm
Rh22_6 n22_6 n22_7 100
Rv22_6 n22_6 n23_6 100
D22_7 n22_7 0 dm
Rh22_7 n22_7 n22_8 100
Rv22_7 n22_7 n23_7 100
D22_8 n22_8 0 dm
Rh22_8 n22_8 n22_9 100
Rv22_8 n22_8 n23_8 100
D22_9 n22_9 0 dm
Rh22_9 n22_9 n22_10 100
Rv22_9 n22_9 n23_9 100
D22_10 n22_10 0 dm
Rh22_10 n22_10 n22_11 100
Rv22_10 n22_10 n23_10 100
D22_11 n22_11 0 dm
Rh22_11 n22_11 n22_12 100
Rv22_11 n22_11 n23_11 100
D22_12 n22_12 0 dm
Rh22_12 n22_12 n22_13 100
Rv22_12 n22_12 n23_12 100
D22_13 n22_13 0 dm
Rh22_13 n22_13 n22_14 100
Rv22_13 n22_13 n23_13 100
D22_14 n22_14 0 dm
Rh22_14 n22_14 n22_15 100
Rv22_14 n22_14 n23_14 100
D22_15 n22_15 0 dm
Rh22_15 n22_15 n22_16 100
Rv22_15 n22_15 n23_15 100
D22_16 n22_16 0 dm
Rh22_16 n22_16 n22_17 100
Rv22_16 n22_16 n23_16 100
D22_17 n22_17 0 dm
Rh22_17 n22_17 n22_18 100
Rv22_17 n22_17 n23_17 100
D22_18 n22_18 0 dm
Rh22_18 n22_18 n22_19 100
Rv22_18 n22_18 n23_18 100
D22_19 n22_19 0 dm
Rh22_19 n22_19 n22_20 100
Rv22_19 n22_19 n23_19 100
D22_20 n22_20 0 dm
Rh22_20 n22_20 n22_21 100
Rv22_20 n22_20 n23_20 100
D22_21 n22_21 0 dm
Rh22_21 n22_21 n22_22 100
Rv22_21 n22_21 n23_21 100
D22_22 n22_22 0 dm
Rh22_22 n22_22 n22_23 100
Rv22_22 n22_22 n23_22 100
D22_23 n22_23 0 dm
Rh22_23 n22_23 n22_24 100
Rv22_23 n22_23 n23_23 100
D22_24 n22_24 0 dm
Rh22_24 n22_24 n22_25 100
Rv22_24 n22_24 n23_24 100
D22_25 n22_25 0 dm
Rh22_25 n22_25 n22_26 100
Rv22_25 n22_25 n23_25 100
D22_26 n22_26 0 dm
Rh22_26 n22_26 n22_27 100
Rv22_26 n22_26 n23_26 100
D22_27 n22_27 0 dm
Rh22_27 n22_27 n22_28 100
Rv22_27 n22_27 n23_27 100
D22_28 n22_28 0 dm
Rh22_28 n22_28 n22_29 100
Rv22_28 n22_28 n23_28 100
D22_29 n22_29 0 dm
Rh22_29 n22_29 n22_30 100
Rv22_29 n22_29 n23_29 100
D22_30 n22_30 0 dm
Rh22_30 n22_30 n22_31 100
Rv22_30 n22_30 n23_30 100
D22_31 n22_31 0 dm
Rv22_31 n22_31 n23_31 100
D23_0 n23_0 0 dm
Rh23_0 n23_0 n23_1 100
Rv23_0 n23_0 n24_0 100
D23_1 n23_1 0 dm
Rh23_1 n23_1 n23_2 100
Rv23_1 n23_1 n24_1 100
D23_2 n23_2 0 dm
Rh23_2 n23_2 n23_3 100
Rv23_2 n23_2 n24_2 100
D23_3 n23_3 0 dm
Rh23_3 n23_3 n23_4 100
Rv23_3 n23_3 n24_3 100
D23_4 n23_4 0 dm
Rh23_4 n23_4 n23_5 100
Rv23_4 n23_4 n24_4 100
D23_5 n23_5 0 dm
Rh23_5 n23_5 n23_6 100
Rv23_5 n23_5 n24_5 100
D23_6 n23_6 0 dm
Rh23_6 n23_6 n23_7 100
Rv23_6 n23_6 n24_6 100
D23_7 n23_7 0 dm
Rh23_7 n23_7 n23_8 100
Rv23_7 n23_7 n24_7 100
D23_8 n23_8 0 dm
Rh23_8 n23_8 n23_9 100
Rv23_8 n23_8 n24_8 100
D23_9 n23_9 0 dm
Rh23_9 n23_9 n23_10 100
Rv23_9 n23_9 n24_9 100
D23_10 n23_10 0 dm
Rh23_10 n23_10 n23_11 100
Rv23_10 n23_10 n24_10 100
D23_11 n23_11 0 dm
Rh23_11 n23_11 n23_12 100
Rv23_11 n23_11 n24_11 100
D23_12 n23_12 0 dm
Rh23_12 n23_12 n23_13 100
Rv23_12 n23_12 n24_12 100
D23_13 n23_13 0 dm
Rh23_13 n23_13 n23_14 100
Rv23_13 n23_13 n24_13 100
D23_14 n23_14 0 dm
Rh23_14 n23_14 n23_15 100
Rv23_14 n23_14 n24_14 100
D23_15 n23_15 0 dm
Rh23_15 n23_15 n23_16 100
Rv23_15 n23_15 n24_15 100
D23_16 n23_16 0 dm
Rh23_16 n23_16 n23_17 100
Rv23_16 n23_16 n24_16 100
D23_17 n23_17 0 dm
Rh23_17 n23_17 n23_18 100
Rv23_17 n23_17 n24_17 100
D23_18 n23_18 0 dm
Rh23_18 n23_18 n23_19 100
Rv23_18 n23_18 n24_18 100
D23_19 n23_19 0 dm
Rh23_19 n23_19 n23_20 100
Rv23_19 n23_19 n24_19 100
D23_20 n23_20 0 dm
Rh23_20 n23_20 n23_21 100
Rv23_20 n23_20 n24_20 100
D23_21 n23_21 0 dm
Rh23_21 n23_21 n23_22 100
Rv23_21 n23_21 n24_21 100
D23_22 n23_22 0 dm
Rh23_22 n23_22 n23_23 100
Rv23_22 n23_22 n24_22 100
D23_23 n23_23 0 dm
Rh23_23 n23_23 n23_24 100
Rv23_23 n23_23 n24_23 100
D23_24 n23_24 0 dm
Rh23_24 n23_24 n23_25 100
Rv23_24 n23_24 n24_24 100
D23_25 n23_25 0 dm
Rh23_25 n23_25 n23_26 100
Rv23_25 n23_25 n24_25 100
D23_26 n23_26 0 dm
Rh23_26 n23_26 n23_27 100
Rv23_26 n23_26 n24_26 100
D23_27 n23_27 0 dm
Rh23_27 n23_27 n23_28 100
Rv23_27 n23_27 n24_27 100
D23_28 n23_28 0 dm
Rh23_28 n23_28 n23_29 100
Rv23_28 n23_28 n24_28 100
D23_29 n23_29 0 dm
Rh23_29 n23_29 n23_30 100
Rv23_29 n23_29 n24_29 100
D23_30 n23_30 0 dm
Rh23_30 n23_30 n23_31 100
Rv23_30 n23_30 n24_30 100
D23_31 n23_31 0 dm
Rv23_31 n23_31 n24_31 100
D24_0 n24_0 0 dm
Rh24_0 n24_0 n24_1 100
Rv24_0 n24_0 n25_0 100
D24_1 n24_1 0 dm
Rh24_1 n24_1 n24_2 100
Rv24_1 n24_1 n25_1 100
D24_2 n24_2 0 dm
Rh24_2 n24_2 n24_3 100
Rv24_2 n24_2 n25_2 100
D24_3 n24_3 0 dm
Rh24_3 n24_3 n24_4 100
Rv24_3 n24_3 n25_3 100
D24_4 n24_4 0 dm
Rh24_4 n24_4 n24_5 100
Rv24_4 n24_4 n25_4 100
D24_5 n24_5 0 dm
Rh24_5 n24_5 n24_6 100
Rv24_5 n24_5 n25_5 100
D24_6 n24_6 0 dm
Rh24_6 n24_6 n24_7 100
Rv24_6 n24_6 n25_6 100
D24_7 n24_7 0 dm
Rh24_7 n24_7 n24_8 100
Rv24_7 n24_7 n25_7 100
D24_8 n24_8 0 dm
Rh24_8 n24_8 n24_9 100
Rv24_8 n24_8 n25_8 100
D24_9 n24_9 0 dm
Rh24_9 n24_9 n24_10 100
Rv24_9 n24_9 n25_9 100
D24_10 n24_10 0 dm
Rh24_10 n24_10 n24_11 100
Rv24_10 n24_10 n25_10 100
D24_11 n24_11 0 dm
Rh24_11 n24_11 n24_12 100
Rv24_11 n24_11 n25_11 100
D24_12 n24_12 0 dm
Rh24_12 n24_12 n24_13 100
Rv24_12 n24_12 n25_12 100
D24_13 n24_13 0 dm
Rh24_13 n24_13 n24_14 100
Rv24_13 n24_13 n25_13 100
D24_14 n24_14 0 dm
Rh24_14 n24_14 n24_15 100
Rv24_14 n24_14 n25_14 100
D24_15 n24_15 0 dm
Rh24_15 n24_15 n24_16 100
Rv24_15 n24_15 n25_15 100
D24_16 n24_16 0 dm
Rh24_16 n24_16 n24_17 100
Rv24_16 n24_16 n25_16 100
D24_17 n24_17 0 dm
Rh24_17 n24_17 n24_18 100
Rv24_17 n24_17 n25_17 100
D24_18 n24_18 0 dm
Rh24_18 n24_18 n24_19 100
Rv24_18 n24_18 n25_18 100
D24_19 n24_19 0 dm
Rh24_19 n24_19 n24_20 100
Rv24_19 n24_19 n25_19 100
D24_20 n24_20 0 dm
Rh24_20 n24_20 n24_21 100
Rv24_20 n24_20 n25_20 100
D24_21 n24_21 0 dm
Rh24_21 n24_21 n24_22 100
Rv24_21 n24_21 n25_21 100
D24_22 n24_22 0 dm
Rh24_22 n24_22 n24_23 100
Rv24_22 n24_22 n25_22 100
D24_23 n24_23 0 dm
Rh24_23 n24_23 n24_24 100
Rv24_23 n24_23 n25_23 100
D24_24 n24_24 0 dm
Rh24_24 n24_24 n24_25 100
Rv24_24 n24_24 n25_24 100
D24_25 n24_25 0 dm
Rh24_25 n24_25 n24_26 100
Rv24_25 n24_25 n25_25 100
D24_26 n24_26 0 dm
Rh24_26 n24_26 n24_27 100
Rv24_26 n24_26 n25_26 100
D24_27 n24_27 0 dm
Rh24_27 n24_27 n24_28 100
Rv24_27 n24_27 n25_27 100
D24_28 n24_28 0 dm
Rh24_28 n24_28 n24_29 100
Rv24_28 n24_28 n25_28 100
D24_29 n24_29 0 dm
Rh24_29 n24_29 n24_30 100
Rv24_29 n24_29 n25_29 100
D24_30 n24_30 0 dm
Rh24_30 n24_30 n24_31 100
Rv24_30 n24_30 n25_30 100
D24_31 n24_31 0 dm
Rv24_31 n24_31 n25_31 100
D25_0 n25_0 0 dm
Rh25_0 n25_0 n25_1 100
Rv25_0 n25_0 n26_0 100
D25_1 n25_1 0 dm
Rh25_1 n25_1 n25_2 100
Rv25_1 n25_1 n26_1 100
D25_2 n25_2 0 dm
Rh25_2 n25_2 n25_3 100
Rv25_2 n25_2 n26_2 100
D25_3 n25_3 0 dm
Rh25_3 n25_3 n25_4 100
Rv25_3 n25_3 n26_3 100
D25_4 n25_4 0 dm
Rh25_4 n25_4 n25_5 100
Rv25_4 n25_4 n26_4 100
D25_5 n25_5 0 dm
Rh25_5 n25_5 n25_6 100
Rv25_5 n25_5 n26_5 100
D25_6 n25_6 0 dm
Rh25_6 n25_6 n25_7 100
Rv25_6 n25_6 n26_6 100
D25_7 n25_7 0 dm
Rh25_7 n25_7 n25_8 100
Rv25_7 n25_7 n26_7 100
D25_8 n25_8 0 dm
Rh25_8 n25_8 n25_9 100
Rv25_8 n25_8 n26_8 100
D25_9 n25_9 0 dm
Rh25_9 n25_9 n25_10 100
Rv25_9 n25_9 n26_9 100
D25_10 n25_10 0 dm
Rh25_10 n25_10 n25_11 100
Rv25_10 n25_10 n26_10 100
D25_11 n25_11 0 dm
Rh25_11 n25_11 n25_12 100
Rv25_11 n25_11 n26_11 100
D25_12 n25_12 0 dm
Rh25_12 n25_12 n25_13 100
Rv25_12 n25_12 n26_12 100
D25_13 n25_13 0 dm
Rh25_13 n25_13 n25_14 100
Rv25_13 n25_13 n26_13 100
D25_14 n25_14 0 dm
Rh25_14 n25_14 n25_15 100
Rv25_14 n25_14 n26_14 100
D25_15 n25_15 0 dm
Rh25_15 n25_15 n25_16 100
Rv25_15 n25_15 n26_15 100
D25_16 n25_16 0 dm
Rh25_16 n25_16 n25_17 100
Rv25_16 n25_16 n26_16 100
D25_17 n25_17 0 dm
Rh25_17 n25_17 n25_18 100
Rv25_17 n25_17 n26_17 100
D25_18 n25_18 0 dm
Rh25_18 n25_18 n25_19 100
Rv25_18 n25_18 n26_18 100
D25_19 n25_19 0 dm
Rh25_19 n25_19 n25_20 100
Rv25_19 n25_19 n26_19 100
D25_20 n25_20 0 dm
Rh25_20 n25_20 n25_21 100
Rv25_20 n25_20 n26_20 100
D25_21 n25_21 0 dm
Rh25_21 n25_21 n25_22 100
Rv25_21 n25_21 n26_21 100
D25_22 n25_22 0 dm
Rh25_22 n25_22 n25_23 100
Rv25_22 n25_22 n26_22 100
D25_23 n25_23 0 dm
Rh25_23 n25_23 n25_24 100
Rv25_23 n25_23 n26_23 100
D25_24 n25_24 0 dm
Rh25_24 n25_24 n25_25 100
Rv25_24 n25_24 n26_24 100
D25_25 n25_25 0 dm
Rh25_25 n25_25 n25_26 100
Rv25_25 n25_25 n26_25 100
D25_26 n25_26 0 dm
Rh25_26 n25_26 n25_27 100
Rv25_26 n25_26 n26_26 100
D25_27 n25_27 0 dm
Rh25_27 n25_27 n25_28 100
Rv25_27 n25_27 n26_27 100
D25_28 n25_28 0 dm
Rh25_28 n25_28 n25_29 100
Rv25_28 n25_28 n26_28 100
D25_29 n25_29 0 dm
Rh25_29 n25_29 n25_30 100
Rv25_29 n25_29 n26_29 100
D25_30 n25_30 0 dm
Rh25_30 n25_30 n25_31 100
Rv25_30 n25_30 n26_30 100
D25_31 n25_31 0 dm
Rv25_31 n25_31 n26_31 100
D26_0 n26_0 0 dm
Rh26_0 n26_0 n26_1 100
Rv26_0 n26_0 n27_0 100
D26_1 n26_1 0 dm
Rh26_1 n26_1 n26_2 100
Rv26_1 n26_1 n27_1 100
D26_2 n26_2 0 dm
Rh26_2 n26_2 n26_3 100
Rv26_2 n26_2 n27_2 100
D26_3 n26_3 0 dm
Rh26_3 n26_3 n26_4 100
Rv26_3 n26_3 n27_3 100
D26_4 n26_4 0 dm
Rh26_4 n26_4 n26_5 100
Rv26_4 n26_4 n27_4 100
D26_5 n26_5 0 dm
Rh26_5 n26_5 n26_6 100
Rv26_5 n26_5 n27_5 100
D26_6 n26_6 0 dm
Rh26_6 n26_6 n26_7 100
Rv26_6 n26_6 n27_6 100
D26_7 n26_7 0 dm
Rh26_7 n26_7 n26_8 100
Rv26_7 n26_7 n27_7 100
D26_8 n26_8 0 dm
Rh26_8 n26_8 n26_9 100
Rv26_8 n26_8 n27_8 100
D26_9 n26_9 0 dm
Rh26_9 n26_9 n26_10 100
Rv26_9 n26_9 n27_9 100
D26_10 n26_10 0 dm
Rh26_10 n26_10 n26_11 100
Rv26_10 n26_10 n27_10 100
D26_11 n26_11 0 dm
Rh26_11 n26_11 n26_12 100
Rv26_11 n26_11 n27_11 100
D26_12 n26_12 0 dm
Rh26_12 n26_12 n26_13 100
Rv26_12 n26_12 n27_12 100
D26_13 n26_13 0 dm
Rh26_13 n26_13 n26_14 100
Rv26_13 n26_13 n27_13 100
D26_14 n26_14 0 dm
Rh26_14 n26_14 n26_15 100
Rv26_14 n26_14 n27_14 100
D26_15 n26_15 0 dm
Rh26_15 n26_15 n26_16 100
Rv26_15 n26_15 n27_15 100
D26_16 n26_16 0 dm
Rh26_16 n26_16 n26_17 100
Rv26_16 n26_16 n27_16 100
D26_17 n26_17 0 dm
Rh26_17 n26_17 n26_18 100
Rv26_17 n26_17 n27_17 100
D26_18 n26_18 0 dm
Rh26_18 n26_18 n26_19 100
Rv26_18 n26_18 n27_18 100
D26_19 n26_19 0 dm
Rh26_19 n26_19 n26_20 100
Rv26_19 n26_19 n27_19 100
D26_20 n26_20 0 dm
Rh26_20 n26_20 n26_21 100
Rv26_20 n26_20 n27_20 100
D26_21 n26_21 0 dm
Rh26_21 n26_21 n26_22 100
Rv26_21 n26_21 n27_21 100
D26_22 n26_22 0 dm
Rh26_22 n26_22 n26_23 100
Rv26_22 n26_22 n27_22 100
D26_23 n26_23 0 dm
Rh26_23 n26_23 n26_24 100
Rv26_23 n26_23 n27_23 100
D26_24 n26_24 0 dm
Rh26_24 n26_24 n26_25 100
Rv26_24 n26_24 n27_24 100
D26_25 n26_25 0 dm
Rh26_25 n26_25 n26_26 100
Rv26_25 n26_25 n27_25 100
D26_26 n26_26 0 dm
Rh26_26 n26_26 n26_27 100
Rv26_26 n26_26 n27_26 100
D26_27 n26_27 0 dm
Rh26_27 n26_27 n26_28 100
Rv26_27 n26_27 n27_27 100
D26_28 n26_28 0 dm
Rh26_28 n26_28 n26_29 100
Rv26_28 n26_28 n27_28 100
D26_29 n26_29 0 dm
Rh26_29 n26_29 n26_30 100
Rv26_29 n26_29 n27_29 100
D26_30 n26_30 0 dm
Rh26_30 n26_30 n26_31 100
Rv26_30 n26_30 n27_30 100
D26_31 n26_31 0 dm
Rv26_31 n26_31 n27_31 100
D27_0 n27_0 0 dm
Rh27_0 n27_0 n27_1 100
Rv27_0 n27_0 n28_0 100
D27_1 n27_1 0 dm
Rh27_1 n27_1 n27_2 100
Rv27_1 n27_1 n28_1 100
D27_2 n27_2 0 dm
Rh27_2 n27_2 n27_3 100
Rv27_2 n27_2 n28_2 100
D27_3 n27_3 0 dm
Rh27_3 n27_3 n27_4 100
Rv27_3 n27_3 n28_3 100
D27_4 n27_4 0 dm
Rh27_4 n27_4 n27_5 100
Rv27_4 n27_4 n28_4 100
D27_5 n27_5 0 dm
Rh27_5 n27_5 n27_6 100
Rv27_5 n27_5 n28_5 100
D27_6 n27_6 0 dm
Rh27_6 n27_6 n27_7 100
Rv27_6 n27_6 n28_6 100
D27_7 n27_7 0 dm
Rh27_7 n27_7 n27_8 100
Rv27_7 n27_7 n28_7 100
D27_8 n27_8 0 dm
Rh27_8 n27_8 n27_9 100
Rv27_8 n27_8 n28_8 100
D27_9 n27_9 0 dm
Rh27_9 n27_9 n27_10 100
Rv27_9 n27_9 n28_9 100
D27_10 n27_10 0 dm
Rh27_10 n27_10 n27_11 100
Rv27_10 n27_10 n28_10 100
D27_11 n27_11 0 dm
Rh27_11 n27_11 n27_12 100
Rv27_11 n27_11 n28_11 100
D27_12 n27_12 0 dm
Rh27_12 n27_12 n27_13 100
Rv27_12 n27_12 n28_12 100
D27_13 n27_13 0 dm
Rh27_13 n27_13 n27_14 100
Rv27_13 n27_13 n28_13 100
D27_14 n27_14 0 dm
Rh27_14 n27_14 n27_15 100
Rv27_14 n27_14 n28_14 100
D27_15 n27_15 0 dm
Rh27_15 n27_15 n27_16 100
Rv27_15 n27_15 n28_15 100
D27_16 n27_16 0 dm
Rh27_16 n27_16 n27_17 100
Rv27_16 n27_16 n28_16 100
D27_17 n27_17 0 dm
Rh27_17 n27_17 n27_18 100
Rv27_17 n27_17 n28_17 100
D27_18 n27_18 0 dm
Rh27_18 n27_18 n27_19 100
Rv27_18 n27_18 n28_18 100
D27_19 n27_19 0 dm
Rh27_19 n27_19 n27_20 100
Rv27_19 n27_19 n28_19 100
D27_20 n27_20 0 dm
Rh27_20 n27_20 n27_21 100
Rv27_20 n27_20 n28_20 100
D27_21 n27_21 0 dm
Rh27_21 n27_21 n27_22 100
Rv27_21 n27_21 n28_21 100
D27_22 n27_22 0 dm
Rh27_22 n27_22 n27_23 100
Rv27_22 n27_22 n28_22 100
D27_23 n27_23 0 dm
Rh27_23 n27_23 n27_24 100
Rv27_23 n27_23 n28_23 100
D27_24 n27_24 0 dm
Rh27_24 n27_24 n27_25 100
Rv27_24 n27_24 n28_24 100
D27_25 n27_25 0 dm
Rh27_25 n27_25 n27_26 100
Rv27_25 n27_25 n28_25 100
D27_26 n27_26 0 dm
Rh27_26 n27_26 n27_27 100
Rv27_26 n27_26 n28_26 100
D27_27 n27_27 0 dm
Rh27_27 n27_27 n27_28 100
Rv27_27 n27_27 n28_27 100
D27_28 n27_28 0 dm
Rh27_28 n27_28 n27_29 100
Rv27_28 n27_28 n28_28 100
D27_29 n27_29 0 dm
Rh27_29 n27_29 n27_30 100
Rv27_29 n27_29 n28_29 100
D27_30 n27_30 0 dm
Rh27_30 n27_30 n27_31 100
Rv27_30 n27_30 n28_30 100
D27_31 n27_31 0 dm
Rv27_31 n27_31 n28_31 100
D28_0 n28_0 0 dm
Rh28_0 n28_0 n28_1 100
Rv28_0 n28_0 n29_0 100
D28_1 n28_1 0 dm
Rh28_1 n28_1 n28_2 100
Rv28_1 n28_1 n29_1 100
D28_2 n28_2 0 dm
Rh28_2 n28_2 n28_3 100
Rv28_2 n28_2 n29_2 100
D28_3 n28_3 0 dm
Rh28_3 n28_3 n28_4 100
Rv28_3 n28_3 n29_3 100
D28_4 n28_4 0 dm
Rh28_4 n28_4 n28_5 100
Rv28_4 n28_4 n29_4 100
D28_5 n28_5 0 dm
Rh28_5 n28_5 n28_6 100
Rv28_5 n28_5 n29_5 100
D28_6 n28_6 0 dm
Rh28_6 n28_6 n28_7 100
Rv28_6 n28_6 n29_6 100
D28_7 n28_7 0 dm
Rh28_7 n28_7 n28_8 100
Rv28_7 n28_7 n29_7 100
D28_8 n28_8 0 dm
Rh28_8 n28_8 n28_9 100
Rv28_8 n28_8 n29_8 100
D28_9 n28_9 0 dm
Rh28_9 n28_9 n28_10 100
Rv28_9 n28_9 n29_9 100
D28_10 n28_10 0 dm
Rh28_10 n28_10 n28_11 100
Rv28_10 n28_10 n29_10 100
D28_11 n28_11 0 dm
Rh28_11 n28_11 n28_12 100
Rv28_11 n28_11 n29_11 100
D28_12 n28_12 0 dm
Rh28_12 n28_12 n28_13 100
Rv28_12 n28_12 n29_12 100
D28_13 n28_13 0 dm
Rh28_13 n28_13 n28_14 100
Rv28_13 n28_13 n29_13 100
D28_14 n28_14 0 dm
Rh28_14 n28_14 n28_15 100
Rv28_14 n28_14 n29_14 100
D28_15 n28_15 0 dm
Rh28_15 n28_15 n28_16 100
Rv28_15 n28_15 n29_15 100
D28_16 n28_16 0 dm
Rh28_16 n28_16 n28_17 100
Rv28_16 n28_16 n29_16 100
D28_17 n28_17 0 dm
Rh28_17 n28_17 n28_18 100
Rv28_17 n28_17 n29_17 100
D28_18 n28_18 0 dm
Rh28_18 n28_18 n28_19 100
Rv28_18 n28_18 n29_18 100
D28_19 n28_19 0 dm
Rh28_19 n28_19 n28_20 100
Rv28_19 n28_19 n29_19 100
D28_20 n28_20 0 dm
Rh28_20 n28_20 n28_21 100
Rv28_20 n28_20 n29_20 100
D28_21 n28_21 0 dm
Rh28_21 n28_21 n28_22 100
Rv28_21 n28_21 n29_21 100
D28_22 n28_22 0 dm
Rh28_22 n28_22 n28_23 100
Rv28_22 n28_22 n29_22 100
D28_23 n28_23 0 dm
Rh28_23 n28_23 n28_24 100
Rv28_23 n28_23 n29_23 100
D28_24 n28_24 0 dm
Rh28_24 n28_24 n28_25 100
Rv28_24 n28_24 n29_24 100
D28_25 n28_25 0 dm
Rh28_25 n28_25 n28_26 100
Rv28_25 n28_25 n29_25 100
D28_26 n28_26 0 dm
Rh28_26 n28_26 n28_27 100
Rv28_26 n28_26 n29_26 100
D28_27 n28_27 0 dm
Rh28_27 n28_27 n28_28 100
Rv28_27 n28_27 n29_27 100
D28_28 n28_28 0 dm
Rh28_28 n28_28 n28_29 100
Rv28_28 n28_28 n29_28 100
D28_29 n28_29 0 dm
Rh28_29 n28_29 n28_30 100
Rv28_29 n28_29 n29_29 100
D28_30 n28_30 0 dm
Rh28_30 n28_30 n28_31 100
Rv28_30 n28_30 n29_30 100
D28_31 n28_31 0 dm
Rv28_31 n28_31 n29_31 100
D29_0 n29_0 0 dm
Rh29_0 n29_0 n29_1 100
Rv29_0 n29_0 n30_0 100
D29_1 n29_1 0 dm
Rh29_1 n29_1 n29_2 100
Rv29_1 n29_1 n30_1 100
D29_2 n29_2 0 dm
Rh29_2 n29_2 n29_3 100
Rv29_2 n29_2 n30_2 100
D29_3 n29_3 0 dm
Rh29_3 n29_3 n29_4 100
Rv29_3 n29_3 n30_3 100
D29_4 n29_4 0 dm
Rh29_4 n29_4 n29_5 100
Rv29_4 n29_4 n30_4 100
D29_5 n29_5 0 dm
Rh29_5 n29_5 n29_6 100
Rv29_5 n29_5 n30_5 100
D29_6 n29_6 0 dm
Rh29_6 n29_6 n29_7 100
Rv29_6 n29_6 n30_6 100
D29_7 n29_7 0 dm
Rh29_7 n29_7 n29_8 100
Rv29_7 n29_7 n30_7 100
D29_8 n29_8 0 dm
Rh29_8 n29_8 n29_9 100
Rv29_8 n29_8 n30_8 100
D29_9 n29_9 0 dm
Rh29_9 n29_9 n29_10 100
Rv29_9 n29_9 n30_9 100
D29_10 n29_10 0 dm
Rh29_10 n29_10 n29_11 100
Rv29_10 n29_10 n30_10 100
D29_11 n29_11 0 dm
Rh29_11 n29_11 n29_12 100
Rv29_11 n29_11 n30_11 100
D29_12 n29_12 0 dm
Rh29_12 n29_12 n29_13 100
Rv29_12 n29_12 n30_12 100
D29_13 n29_13 0 dm
Rh29_13 n29_13 n29_14 100
Rv29_13 n29_13 n30_13 100
D29_14 n29_14 0 dm
Rh29_14 n29_14 n29_15 100
Rv29_14 n29_14 n30_14 100
D29_15 n29_15 0 dm
Rh29_15 n29_15 n29_16 100
Rv29_15 n29_15 n30_15 100
D29_16 n29_16 0 dm
Rh29_16 n29_16 n29_17 100
Rv29_16 n29_16 n30_16 100
D29_17 n29_17 0 dm
Rh29_17 n29_17 n29_18 100
Rv29_17 n29_17 n30_17 100
D29_18 n29_18 0 dm
Rh29_18 n29_18 n29_19 100
Rv29_18 n29_18 n30_18 100
D29_19 n29_19 0 dm
Rh29_19 n29_19 n29_20 100
Rv29_19 n29_19 n30_19 100
D29_20 n29_20 0 dm
Rh29_20 n29_20 n29_21 100
Rv29_20 n29_20 n30_20 100
D29_21 n29_21 0 dm
Rh29_21 n29_21 n29_22 100
Rv29_21 n29_21 n30_21 100
D29_22 n29_22 0 dm
Rh29_22 n29_22 n29_23 100
Rv29_22 n29_22 n30_22 100
D29_23 n29_23 0 dm
Rh29_23 n29_23 n29_24 100
Rv29_23 n29_23 n30_23 100
D29_24 n29_24 0 dm
Rh29_24 n29_24 n29_25 100
Rv29_24 n29_24 n30_24 100
D29_25 n29_25 0 dm
Rh29_25 n29_25 n29_26 100
Rv29_25 n29_25 n30_25 100
D29_26 n29_26 0 dm
Rh29_26 n29_26 n29_27 100
Rv29_26 n29_26 n30_26 100
D29_27 n29_27 0 dm
Rh29_27 n29_27 n29_28 100
Rv29_27 n29_27 n30_27 100
D29_28 n29_28 0 dm
Rh29_28 n29_28 n29_29 100
Rv29_28 n29_28 n30_28 100
D29_29 n29_29 0 dm
Rh29_29 n29_29 n29_30 100
Rv29_29 n29_29 n30_29 100
D29_30 n29_30 0 dm
Rh29_30 n29_30 n29_31 100
Rv29_30 n29_30 n30_30 100
D29_31 n29_31 0 dm
Rv29_31 n29_31 n30_31 100
D30_0 n30_0 0 dm
Rh30_0 n30_0 n30_1 100
Rv30_0 n30_0 n31_0 100
D30_1 n30_1 0 dm
Rh30_1 n30_1 n30_2 100
Rv30_1 n30_1 n31_1 100
D30_2 n30_2 0 dm
Rh30_2 n30_2 n30_3 100
Rv30_2 n30_2 n31_2 100
D30_3 n30_3 0 dm
Rh30_3 n30_3 n30_4 100
Rv30_3 n30_3 n31_3 100
D30_4 n30_4 0 dm
Rh30_4 n30_4 n30_5 100
Rv30_4 n30_4 n31_4 100
D30_5 n30_5 0 dm
Rh30_5 n30_5 n30_6 100
Rv30_5 n30_5 n31_5 100
D30_6 n30_6 0 dm
Rh30_6 n30_6 n30_7 100
Rv30_6 n30_6 n31_6 100
D30_7 n30_7 0 dm
Rh30_7 n30_7 n30_8 100
Rv30_7 n30_7 n31_7 100
D30_8 n30_8 0 dm
Rh30_8 n30_8 n30_9 100
Rv30_8 n30_8 n31_8 100
D30_9 n30_9 0 dm
Rh30_9 n30_9 n30_10 100
Rv30_9 n30_9 n31_9 100
D30_10 n30_10 0 dm
Rh30_10 n30_10 n30_11 100
Rv30_10 n30_10 n31_10 100
D30_11 n30_11 0 dm
Rh30_11 n30_11 n30_12 100
Rv30_11 n30_11 n31_11 100
D30_12 n30_12 0 dm
Rh30_12 n30_12 n30_13 100
Rv30_12 n30_12 n31_12 100
D30_13 n30_13 0 dm
Rh30_13 n30_13 n30_14 100
Rv30_13 n30_13 n31_13 100
D30_14 n30_14 0 dm
Rh30_14 n30_14 n30_15 100
Rv30_14 n30_14 n31_14 100
D30_15 n30_15 0 dm
Rh30_15 n30_15 n30_16 100
Rv30_15 n30_15 n31_15 100
D30_16 n30_16 0 dm
Rh30_16 n30_16 n30_17 100
Rv30_16 n30_16 n31_16 100
D30_17 n30_17 0 dm
Rh30_17 n30_17 n30_18 100
Rv30_17 n30_17 n31_17 100
D30_18 n30_18 0 dm
Rh30_18 n30_18 n30_19 100
Rv30_18 n30_18 n31_18 100
D30_19 n30_19 0 dm
Rh30_19 n30_19 n30_20 100
Rv30_19 n30_19 n31_19 100
D30_20 n30_20 0 dm
Rh30_20 n30_20 n30_21 100
Rv30_20 n30_20 n31_20 100
D30_21 n30_21 0 dm
Rh30_21 n30_21 n30_22 100
Rv30_21 n30_21 n31_21 100
D30_22 n30_22 0 dm
Rh30_22 n30_22 n30_23 100
Rv30_22 n30_22 n31_22 100
D30_23 n30_23 0 dm
Rh30_23 n30_23 n30_24 100
Rv30_23 n30_23 n31_23 100
D30_24 n30_24 0 dm
Rh30_24 n30_24 n30_25 100
Rv30_24 n30_24 n31_24 100
D30_25 n30_25 0 dm
Rh30_25 n30_25 n30_26 100
Rv30_25 n30_25 n31_25 100
D30_26 n30_26 0 dm
Rh30_26 n30_26 n30_27 100
Rv30_26 n30_26 n31_26 100
D30_27 n30_27 0 dm
Rh30_27 n30_27 n30_28 100
Rv30_27 n30_27 n31_27 100
D30_28 n30_28 0 dm
Rh30_28 n30_28 n30_29 100
Rv30_28 n30_28 n31_28 100
D30_29 n30_29 0 dm
Rh30_29 n30_29 n30_30 100
Rv30_29 n30_29 n31_29 100
D30_30 n30_30 0 dm
Rh30_30 n30_30 n30_31 100
Rv30_30 n30_30 n31_30 100
D30_31 n30_31 0 dm
Rv30_31 n30_31 n31_31 100
D31_0 n31_0 0 dm
Rh31_0 n31_0 n31_1 100
D31_1 n31_1 0 dm
Rh31_1 n31_1 n31_2 100
D31_2 n31_2 0 dm
Rh31_2 n31_2 n31_3 100
D31_3 n31_3 0 dm
Rh31_3 n31_3 n31_4 100
D31_4 n31_4 0 dm
Rh31_4 n31_4 n31_5 100
D31_5 n31_5 0 dm
Rh31_5 n31_5 n31_6 100
D31_6 n31_6 0 dm
Rh31_6 n31_6 n31_7 100
D31_7 n31_7 0 dm
Rh31_7 n31_7 n31_8 100
D31_8 n31_8 0 dm
Rh31_8 n31_8 n31_9 100
D31_9 n31_9 0 dm
Rh31_9 n31_9 n31_10 100
D31_10 n31_10 0 dm
Rh31_10 n31_10 n31_11 100
D31_11 n31_11 0 dm
Rh31_11 n31_11 n31_12 100
D31_12 n31_12 0 dm
Rh31_12 n31_12 n31_13 100
D31_13 n31_13 0 dm
Rh31_13 n31_13 n31_14 100
D31_14 n31_14 0 dm
Rh31_14 n31_14 n31_15 100
D31_15 n31_15 0 dm
Rh31_15 n31_15 n31_16 100
D31_16 n31_16 0 dm
Rh31_16 n31_16 n31_17 100
D31_17 n31_17 0 dm
Rh31_17 n31_17 n31_18 100
D31_18 n31_18 0 dm
Rh31_18 n31_18 n31_19 100
D31_19 n31_19 0 dm
Rh31_19 n31_19 n31_20 100
D31_20 n31_20 0 dm
Rh31_20 n31_20 n31_21 100
D31_21 n31_21 0 dm
Rh31_21 n31_21 n31_22 100
D31_22 n31_22 0 dm
Rh31_22 n31_22 n31_23 100
D31_23 n31_23 0 dm
Rh31_23 n31_23 n31_24 100
D31_24 n31_24 0 dm
Rh31_24 n31_24 n31_25 100
D31_25 n31_25 0 dm
Rh31_25 n31_25 n31_26 100
D31_26 n31_26 0 dm
Rh31_26 n31_26 n31_27 100
D31_27 n31_27 0 dm
Rh31_27 n31_27 n31_28 100
D31_28 n31_28 0 dm
Rh31_28 n31_28 n31_29 100
D31_29 n31_29 0 dm
Rh31_29 n31_29 n31_30 100
D31_30 n31_30 0 dm
Rh31_30 n31_30 n31_31 100
D31_31 n31_31 0 dm
.op
.end
