CMOS inverter chain with 100 stages, one operating point
* bench.id: perf_med_cmos_chain_op_100
* bench.group: performance
* bench.title: CMOS inverter chain with 100 stages, one operating point
* bench.probes: v(n1), v(n50), v(n100), i(vdd)
* bench.tol.rel: 1e-6
* bench.tol.abs: 1e-9
* bench.expect: match
* bench.ng.solver: both
* bench.timing: yes
* bench.size: 104
* bench.est_rss_mib: 10
* bench.tags: nonlinear, op, cmos, chain, medium
* bench.note: 200 MOSFETs, 104 unknowns, banded structure: Newton from a zero start has to propagate the logic levels down the chain
.model nm NMOS(LEVEL=1 VTO=0.7 KP=100u LAMBDA=0.02)
.model pm PMOS(LEVEL=1 VTO=-0.7 KP=50u LAMBDA=0.02)
VDD vdd 0 3
VIN in0 0 3
MP1 n1 in0 vdd vdd pm W=20u L=1u
MN1 n1 in0 0 0 nm W=10u L=1u
MP2 n2 n1 vdd vdd pm W=20u L=1u
MN2 n2 n1 0 0 nm W=10u L=1u
MP3 n3 n2 vdd vdd pm W=20u L=1u
MN3 n3 n2 0 0 nm W=10u L=1u
MP4 n4 n3 vdd vdd pm W=20u L=1u
MN4 n4 n3 0 0 nm W=10u L=1u
MP5 n5 n4 vdd vdd pm W=20u L=1u
MN5 n5 n4 0 0 nm W=10u L=1u
MP6 n6 n5 vdd vdd pm W=20u L=1u
MN6 n6 n5 0 0 nm W=10u L=1u
MP7 n7 n6 vdd vdd pm W=20u L=1u
MN7 n7 n6 0 0 nm W=10u L=1u
MP8 n8 n7 vdd vdd pm W=20u L=1u
MN8 n8 n7 0 0 nm W=10u L=1u
MP9 n9 n8 vdd vdd pm W=20u L=1u
MN9 n9 n8 0 0 nm W=10u L=1u
MP10 n10 n9 vdd vdd pm W=20u L=1u
MN10 n10 n9 0 0 nm W=10u L=1u
MP11 n11 n10 vdd vdd pm W=20u L=1u
MN11 n11 n10 0 0 nm W=10u L=1u
MP12 n12 n11 vdd vdd pm W=20u L=1u
MN12 n12 n11 0 0 nm W=10u L=1u
MP13 n13 n12 vdd vdd pm W=20u L=1u
MN13 n13 n12 0 0 nm W=10u L=1u
MP14 n14 n13 vdd vdd pm W=20u L=1u
MN14 n14 n13 0 0 nm W=10u L=1u
MP15 n15 n14 vdd vdd pm W=20u L=1u
MN15 n15 n14 0 0 nm W=10u L=1u
MP16 n16 n15 vdd vdd pm W=20u L=1u
MN16 n16 n15 0 0 nm W=10u L=1u
MP17 n17 n16 vdd vdd pm W=20u L=1u
MN17 n17 n16 0 0 nm W=10u L=1u
MP18 n18 n17 vdd vdd pm W=20u L=1u
MN18 n18 n17 0 0 nm W=10u L=1u
MP19 n19 n18 vdd vdd pm W=20u L=1u
MN19 n19 n18 0 0 nm W=10u L=1u
MP20 n20 n19 vdd vdd pm W=20u L=1u
MN20 n20 n19 0 0 nm W=10u L=1u
MP21 n21 n20 vdd vdd pm W=20u L=1u
MN21 n21 n20 0 0 nm W=10u L=1u
MP22 n22 n21 vdd vdd pm W=20u L=1u
MN22 n22 n21 0 0 nm W=10u L=1u
MP23 n23 n22 vdd vdd pm W=20u L=1u
MN23 n23 n22 0 0 nm W=10u L=1u
MP24 n24 n23 vdd vdd pm W=20u L=1u
MN24 n24 n23 0 0 nm W=10u L=1u
MP25 n25 n24 vdd vdd pm W=20u L=1u
MN25 n25 n24 0 0 nm W=10u L=1u
MP26 n26 n25 vdd vdd pm W=20u L=1u
MN26 n26 n25 0 0 nm W=10u L=1u
MP27 n27 n26 vdd vdd pm W=20u L=1u
MN27 n27 n26 0 0 nm W=10u L=1u
MP28 n28 n27 vdd vdd pm W=20u L=1u
MN28 n28 n27 0 0 nm W=10u L=1u
MP29 n29 n28 vdd vdd pm W=20u L=1u
MN29 n29 n28 0 0 nm W=10u L=1u
MP30 n30 n29 vdd vdd pm W=20u L=1u
MN30 n30 n29 0 0 nm W=10u L=1u
MP31 n31 n30 vdd vdd pm W=20u L=1u
MN31 n31 n30 0 0 nm W=10u L=1u
MP32 n32 n31 vdd vdd pm W=20u L=1u
MN32 n32 n31 0 0 nm W=10u L=1u
MP33 n33 n32 vdd vdd pm W=20u L=1u
MN33 n33 n32 0 0 nm W=10u L=1u
MP34 n34 n33 vdd vdd pm W=20u L=1u
MN34 n34 n33 0 0 nm W=10u L=1u
MP35 n35 n34 vdd vdd pm W=20u L=1u
MN35 n35 n34 0 0 nm W=10u L=1u
MP36 n36 n35 vdd vdd pm W=20u L=1u
MN36 n36 n35 0 0 nm W=10u L=1u
MP37 n37 n36 vdd vdd pm W=20u L=1u
MN37 n37 n36 0 0 nm W=10u L=1u
MP38 n38 n37 vdd vdd pm W=20u L=1u
MN38 n38 n37 0 0 nm W=10u L=1u
MP39 n39 n38 vdd vdd pm W=20u L=1u
MN39 n39 n38 0 0 nm W=10u L=1u
MP40 n40 n39 vdd vdd pm W=20u L=1u
MN40 n40 n39 0 0 nm W=10u L=1u
MP41 n41 n40 vdd vdd pm W=20u L=1u
MN41 n41 n40 0 0 nm W=10u L=1u
MP42 n42 n41 vdd vdd pm W=20u L=1u
MN42 n42 n41 0 0 nm W=10u L=1u
MP43 n43 n42 vdd vdd pm W=20u L=1u
MN43 n43 n42 0 0 nm W=10u L=1u
MP44 n44 n43 vdd vdd pm W=20u L=1u
MN44 n44 n43 0 0 nm W=10u L=1u
MP45 n45 n44 vdd vdd pm W=20u L=1u
MN45 n45 n44 0 0 nm W=10u L=1u
MP46 n46 n45 vdd vdd pm W=20u L=1u
MN46 n46 n45 0 0 nm W=10u L=1u
MP47 n47 n46 vdd vdd pm W=20u L=1u
MN47 n47 n46 0 0 nm W=10u L=1u
MP48 n48 n47 vdd vdd pm W=20u L=1u
MN48 n48 n47 0 0 nm W=10u L=1u
MP49 n49 n48 vdd vdd pm W=20u L=1u
MN49 n49 n48 0 0 nm W=10u L=1u
MP50 n50 n49 vdd vdd pm W=20u L=1u
MN50 n50 n49 0 0 nm W=10u L=1u
MP51 n51 n50 vdd vdd pm W=20u L=1u
MN51 n51 n50 0 0 nm W=10u L=1u
MP52 n52 n51 vdd vdd pm W=20u L=1u
MN52 n52 n51 0 0 nm W=10u L=1u
MP53 n53 n52 vdd vdd pm W=20u L=1u
MN53 n53 n52 0 0 nm W=10u L=1u
MP54 n54 n53 vdd vdd pm W=20u L=1u
MN54 n54 n53 0 0 nm W=10u L=1u
MP55 n55 n54 vdd vdd pm W=20u L=1u
MN55 n55 n54 0 0 nm W=10u L=1u
MP56 n56 n55 vdd vdd pm W=20u L=1u
MN56 n56 n55 0 0 nm W=10u L=1u
MP57 n57 n56 vdd vdd pm W=20u L=1u
MN57 n57 n56 0 0 nm W=10u L=1u
MP58 n58 n57 vdd vdd pm W=20u L=1u
MN58 n58 n57 0 0 nm W=10u L=1u
MP59 n59 n58 vdd vdd pm W=20u L=1u
MN59 n59 n58 0 0 nm W=10u L=1u
MP60 n60 n59 vdd vdd pm W=20u L=1u
MN60 n60 n59 0 0 nm W=10u L=1u
MP61 n61 n60 vdd vdd pm W=20u L=1u
MN61 n61 n60 0 0 nm W=10u L=1u
MP62 n62 n61 vdd vdd pm W=20u L=1u
MN62 n62 n61 0 0 nm W=10u L=1u
MP63 n63 n62 vdd vdd pm W=20u L=1u
MN63 n63 n62 0 0 nm W=10u L=1u
MP64 n64 n63 vdd vdd pm W=20u L=1u
MN64 n64 n63 0 0 nm W=10u L=1u
MP65 n65 n64 vdd vdd pm W=20u L=1u
MN65 n65 n64 0 0 nm W=10u L=1u
MP66 n66 n65 vdd vdd pm W=20u L=1u
MN66 n66 n65 0 0 nm W=10u L=1u
MP67 n67 n66 vdd vdd pm W=20u L=1u
MN67 n67 n66 0 0 nm W=10u L=1u
MP68 n68 n67 vdd vdd pm W=20u L=1u
MN68 n68 n67 0 0 nm W=10u L=1u
MP69 n69 n68 vdd vdd pm W=20u L=1u
MN69 n69 n68 0 0 nm W=10u L=1u
MP70 n70 n69 vdd vdd pm W=20u L=1u
MN70 n70 n69 0 0 nm W=10u L=1u
MP71 n71 n70 vdd vdd pm W=20u L=1u
MN71 n71 n70 0 0 nm W=10u L=1u
MP72 n72 n71 vdd vdd pm W=20u L=1u
MN72 n72 n71 0 0 nm W=10u L=1u
MP73 n73 n72 vdd vdd pm W=20u L=1u
MN73 n73 n72 0 0 nm W=10u L=1u
MP74 n74 n73 vdd vdd pm W=20u L=1u
MN74 n74 n73 0 0 nm W=10u L=1u
MP75 n75 n74 vdd vdd pm W=20u L=1u
MN75 n75 n74 0 0 nm W=10u L=1u
MP76 n76 n75 vdd vdd pm W=20u L=1u
MN76 n76 n75 0 0 nm W=10u L=1u
MP77 n77 n76 vdd vdd pm W=20u L=1u
MN77 n77 n76 0 0 nm W=10u L=1u
MP78 n78 n77 vdd vdd pm W=20u L=1u
MN78 n78 n77 0 0 nm W=10u L=1u
MP79 n79 n78 vdd vdd pm W=20u L=1u
MN79 n79 n78 0 0 nm W=10u L=1u
MP80 n80 n79 vdd vdd pm W=20u L=1u
MN80 n80 n79 0 0 nm W=10u L=1u
MP81 n81 n80 vdd vdd pm W=20u L=1u
MN81 n81 n80 0 0 nm W=10u L=1u
MP82 n82 n81 vdd vdd pm W=20u L=1u
MN82 n82 n81 0 0 nm W=10u L=1u
MP83 n83 n82 vdd vdd pm W=20u L=1u
MN83 n83 n82 0 0 nm W=10u L=1u
MP84 n84 n83 vdd vdd pm W=20u L=1u
MN84 n84 n83 0 0 nm W=10u L=1u
MP85 n85 n84 vdd vdd pm W=20u L=1u
MN85 n85 n84 0 0 nm W=10u L=1u
MP86 n86 n85 vdd vdd pm W=20u L=1u
MN86 n86 n85 0 0 nm W=10u L=1u
MP87 n87 n86 vdd vdd pm W=20u L=1u
MN87 n87 n86 0 0 nm W=10u L=1u
MP88 n88 n87 vdd vdd pm W=20u L=1u
MN88 n88 n87 0 0 nm W=10u L=1u
MP89 n89 n88 vdd vdd pm W=20u L=1u
MN89 n89 n88 0 0 nm W=10u L=1u
MP90 n90 n89 vdd vdd pm W=20u L=1u
MN90 n90 n89 0 0 nm W=10u L=1u
MP91 n91 n90 vdd vdd pm W=20u L=1u
MN91 n91 n90 0 0 nm W=10u L=1u
MP92 n92 n91 vdd vdd pm W=20u L=1u
MN92 n92 n91 0 0 nm W=10u L=1u
MP93 n93 n92 vdd vdd pm W=20u L=1u
MN93 n93 n92 0 0 nm W=10u L=1u
MP94 n94 n93 vdd vdd pm W=20u L=1u
MN94 n94 n93 0 0 nm W=10u L=1u
MP95 n95 n94 vdd vdd pm W=20u L=1u
MN95 n95 n94 0 0 nm W=10u L=1u
MP96 n96 n95 vdd vdd pm W=20u L=1u
MN96 n96 n95 0 0 nm W=10u L=1u
MP97 n97 n96 vdd vdd pm W=20u L=1u
MN97 n97 n96 0 0 nm W=10u L=1u
MP98 n98 n97 vdd vdd pm W=20u L=1u
MN98 n98 n97 0 0 nm W=10u L=1u
MP99 n99 n98 vdd vdd pm W=20u L=1u
MN99 n99 n98 0 0 nm W=10u L=1u
MP100 n100 n99 vdd vdd pm W=20u L=1u
MN100 n100 n99 0 0 nm W=10u L=1u
.op
.end
